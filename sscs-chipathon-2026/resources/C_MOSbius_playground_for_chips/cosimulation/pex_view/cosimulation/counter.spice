* NGSPICE file created from counter.ext - technology: gf180mcuD

.subckt gf180mcu_fd_sc_mcu7t5v0__fillcap_4 VDD VSS VNW VPW a_36_472# a_124_375#
X0 a_124_375# a_36_472# VSS.t0 VPW.t0 nfet_05v0 ad=0.3608p pd=2.52u as=0.3608p ps=2.52u w=0.82u l=1u
X1 VDD.t0 a_124_375# a_36_472# VNW.t0 pfet_05v0 ad=0.5368p pd=3.32u as=0.5368p ps=3.32u w=1.22u l=1u
R0 VSS VSS.t0 8.62532
R1 VDD VDD.t0 4.47435
R2 VNW VNW.t0 306.452
R3 VPW VPW.t0 875.404
C0 a_36_472# VNW 0.04598f
C1 a_124_375# a_36_472# 0.30831f
C2 a_124_375# VNW 0.19423f
C3 VDD VSS 0.00659f
C4 VSS a_36_472# 0.15579f
C5 VSS VNW 0.00441f
C6 VSS a_124_375# 0.08363f
C7 VDD a_36_472# 0.09598f
C8 VDD VNW 0.07903f
C9 VDD a_124_375# 0.14099f
C10 VSS VPW 0.4239f
C11 VDD VPW 0.42115f
C12 VNW VPW 1.07657f
C13 a_36_472# VPW 0.28579f
C14 a_124_375# VPW 0.12596f
C15 VNW.t0 VPW 0.21056f
C16 VDD.t0 VPW 0.06623f
C17 VSS.t0 VPW 0.04155f
.ends

.subckt gf180mcu_fd_sc_mcu7t5v0__xnor2_1 VDD VSS ZN A1 A2 VNW VPW a_272_93# a_716_68#
+ a_930_497# a_64_93#
X0 ZN.t0 a_64_93# VDD.t0 VNW.t0 pfet_05v0 ad=0.31207p pd=1.665u as=0.34437p ps=1.895u w=1.095u l=0.5u
X1 a_272_93# A2.t1 a_64_93# VPW.t3 nfet_05v0 ad=57.59999f pd=0.68u as=0.1584p ps=1.6u w=0.36u l=0.6u
X2 VSS A1.t1 a_272_93# VPW.t1 nfet_05v0 ad=0.218p pd=1.52u as=57.59999f ps=0.68u w=0.36u l=0.6u
X3 a_716_68# a_64_93# VSS VPW.t0 nfet_05v0 ad=0.2132p pd=1.34u as=0.218p ps=1.52u w=0.82u l=0.6u
X4 VDD.t2 A2.t2 a_930_497# VNW.t4 pfet_05v0 ad=0.4818p pd=3.07u as=0.55297p ps=2.105u w=1.095u l=0.5u
X5 ZN.t3 A1.t0 a_716_68# VPW.t2 nfet_05v0 ad=0.4161p pd=1.905u as=0.2132p ps=1.34u w=0.82u l=0.6u
X6 a_64_93# A2.t3 VDD.t3 VNW.t3 pfet_05v0 ad=0.1456p pd=1.08u as=0.2464p ps=2u w=0.56u l=0.5u
X7 a_716_68# A2.t0 ZN.t1 VPW.t4 nfet_05v0 ad=0.3608p pd=2.52u as=0.4161p ps=1.905u w=0.82u l=0.6u
X8 VDD.t1 A1.t3 a_64_93# VNW.t1 pfet_05v0 ad=0.34437p pd=1.895u as=0.1456p ps=1.08u w=0.56u l=0.5u
X9 a_930_497# A1.t2 ZN.t2 VNW.t2 pfet_05v0 ad=0.55297p pd=2.105u as=0.31207p ps=1.665u w=1.095u l=0.5u
R0 ZN ZN.n1 7.28458
R1 ZN ZN.n0 6.00211
R2 ZN.n1 ZN.t1 3.6883
R3 ZN.n1 ZN.t3 3.6883
R4 ZN.n0 ZN.t0 1.98224
R5 ZN.n0 ZN.t2 1.6626
R6 VDD VDD.t3 8.64224
R7 VDD.n0 VDD.t1 6.7505
R8 VDD.n1 VDD.n0 5.34344
R9 VDD.n1 VDD.t2 4.99238
R10 VDD.n0 VDD.t0 1.66185
R11 VDD VDD.n1 0.368065
R12 A2.n0 A2.t2 20.5135
R13 A2.n1 A2.t3 18.5425
R14 A2.n1 A2.t1 14.053
R15 A2.n0 A2.t0 11.4372
R16 A2 A2.n1 9.08093
R17 A2 A2.n0 8.96449
R18 A1.n1 A1.t3 20.2945
R19 A1.n0 A1.t0 16.3282
R20 A1.n0 A1.t2 15.6225
R21 A1.n1 A1.t1 12.301
R22 A1 A1.n0 8.4405
R23 A1 A1.n1 8.36272
R24 VNW.t2 VNW.t4 564.769
R25 VNW.t1 VNW.t0 501.932
R26 VNW.t0 VNW.t2 413.127
R27 VNW.t3 VNW.t1 393.822
R28 VNW VNW.t3 256.757
R29 VPW.t2 VPW.t4 2315.07
R30 VPW.t1 VPW.t0 1929.22
R31 VPW.t0 VPW.t2 1662.1
R32 VPW.t3 VPW.t1 1365.3
R33 VPW VPW.t3 1068.49
C0 ZN VSS 0.00474f
C1 A2 VDD 0.16669f
C2 a_64_93# VSS 0.3535f
C3 a_930_497# ZN 0.03123f
C4 a_64_93# a_930_497# 0
C5 VSS VDD 0.01142f
C6 a_930_497# VDD 0.01437f
C7 a_272_93# VSS 0.00372f
C8 a_716_68# VNW 0.00323f
C9 a_716_68# A2 0.02593f
C10 ZN A1 0.02385f
C11 a_64_93# A1 0.36559f
C12 VSS a_716_68# 0.70652f
C13 A1 VDD 0.04054f
C14 a_64_93# ZN 0.02696f
C15 VNW A2 0.35997f
C16 ZN VDD 0.4908f
C17 a_64_93# VDD 0.31457f
C18 VSS VNW 0.00897f
C19 VSS A2 0.03599f
C20 a_64_93# a_272_93# 0.00372f
C21 a_930_497# A2 0.01236f
C22 a_716_68# A1 0.06672f
C23 ZN a_716_68# 0.38357f
C24 a_64_93# a_716_68# 0.00587f
C25 VNW A1 0.314f
C26 a_716_68# VDD 0.00191f
C27 A1 A2 0.72514f
C28 ZN VNW 0.02691f
C29 a_64_93# VNW 0.16451f
C30 ZN A2 0.82576f
C31 VSS A1 0.04585f
C32 a_64_93# A2 0.47794f
C33 VNW VDD 0.22108f
C34 VSS VPW 1.65248f
C35 ZN VPW 1.00575f
C36 VDD VPW 0.60491f
C37 A2 VPW 1.37546f
C38 A1 VPW 0.73346f
C39 VNW VPW 2.66751f
C40 a_716_68# VPW 0.0174f
C41 a_64_93# VPW 0.26806f
C42 VNW.t4 VPW 0.31917f
C43 VNW.t2 VPW 0.18186f
C44 VNW.t0 VPW 0.16489f
C45 VNW.t1 VPW 0.16141f
C46 VNW.t3 VPW 0.11723f
C47 A1.t2 VPW 0.18733f
C48 A1.t0 VPW 0.20877f
C49 A1.n0 VPW 0.25345f
C50 A1.t3 VPW 0.16351f
C51 A1.t1 VPW 0.11914f
C52 A1.n1 VPW 0.2727f
C53 A2.t2 VPW 0.30129f
C54 A2.t0 VPW 0.22584f
C55 A2.n0 VPW 0.36927f
C56 A2.t3 VPW 0.2028f
C57 A2.t1 VPW 0.18221f
C58 A2.n1 VPW 0.38676f
C59 VDD.t0 VPW 0.01033f
C60 VDD.t1 VPW 0.02961f
C61 VDD.n0 VPW 0.0957f
C62 VDD.t2 VPW 0.11175f
C63 VDD.n1 VPW 0.74056f
C64 VDD.t3 VPW 0.03608f
C65 ZN.t2 VPW 0.0837f
C66 ZN.t0 VPW 0.0998f
C67 ZN.n0 VPW 0.22212f
C68 ZN.t1 VPW 0.11572f
C69 ZN.t3 VPW 0.11572f
C70 ZN.n1 VPW 0.23776f
.ends

.subckt gf180mcu_fd_sc_mcu7t5v0__dlyb_1 VDD I VSS Z VNW VPW a_671_644# a_895_68# a_523_68#
+ a_47_68# a_503_644# a_1147_68# a_1127_622#
X0 a_523_68# a_47_68# VSS.t2 VPW.t4 nfet_05v0 ad=43.2f pd=0.6u as=93.59999f ps=0.88u w=0.36u l=0.6u
X1 a_671_644# a_47_68# a_523_68# VPW.t5 nfet_05v0 ad=0.369p pd=2.77u as=43.2f ps=0.6u w=0.36u l=0.6u
X2 a_503_644# a_47_68# VDD.t3 VNW.t4 pfet_05v0 ad=61.19999f pd=0.7u as=0.1116p ps=0.98u w=0.36u l=0.5u
X3 VDD.t0 a_671_644# a_1127_622# VNW.t2 pfet_05v0 ad=0.379p pd=2.37u as=61.19999f ps=0.7u w=0.36u l=0.5u
X4 VDD.t2 I.t1 a_47_68# VNW.t0 pfet_05v0 ad=0.1116p pd=0.98u as=0.3852p ps=2.86u w=0.36u l=0.5u
X5 Z.t1 a_895_68# VSS.t1 VPW.t3 nfet_05v0 ad=0.3608p pd=2.52u as=0.28262p ps=1.87u w=0.82u l=0.6u
X6 a_1147_68# a_671_644# a_895_68# VPW.t1 nfet_05v0 ad=43.8f pd=0.605u as=0.3705p ps=2.77u w=0.365u l=0.6u
X7 a_1127_622# a_671_644# a_895_68# VNW.t1 pfet_05v0 ad=61.19999f pd=0.7u as=0.3456p ps=2.64u w=0.36u l=0.5u
X8 VSS.t0 a_671_644# a_1147_68# VPW.t2 nfet_05v0 ad=0.28262p pd=1.87u as=43.8f ps=0.605u w=0.365u l=0.6u
X9 a_671_644# a_47_68# a_503_644# VNW.t5 pfet_05v0 ad=0.3852p pd=2.86u as=61.19999f ps=0.7u w=0.36u l=0.5u
X10 VSS.t3 I.t0 a_47_68# VPW.t0 nfet_05v0 ad=93.59999f pd=0.88u as=0.333p ps=2.57u w=0.36u l=0.6u
X11 Z.t0 a_895_68# VDD.t1 VNW.t3 pfet_05v0 ad=0.5368p pd=3.32u as=0.379p ps=2.37u w=1.22u l=0.5u
R0 VSS.n1 VSS.t1 9.80518
R1 VSS.n2 VSS.n1 7.14859
R2 VSS.n2 VSS.n0 6.35874
R3 VSS.n0 VSS.t2 4.5505
R4 VSS.n0 VSS.t3 4.5505
R5 VSS.n1 VSS.t0 4.48817
R6 VSS VSS.n2 0.05375
R7 Z.n0 Z.t1 8.92356
R8 Z.n0 Z.t0 4.12916
R9 Z Z.n0 0.023
R10 VDD.n1 VDD.t1 11.8234
R11 VDD.n0 VDD.t3 7.0005
R12 VDD.n2 VDD.n1 6.04985
R13 VDD.n2 VDD.n0 5.25874
R14 VDD.n0 VDD.t2 5.05606
R15 VDD.n1 VDD.t0 5.05606
R16 VDD VDD.n2 0.03875
R17 I.n0 I.t1 29.2005
R18 I.n0 I.t0 12.1428
R19 I I.n0 8.19963
R20 VNW.t5 VNW.t1 880.309
R21 VNW.t2 VNW.t3 637.067
R22 VNW.t0 VNW.t4 432.433
R23 VNW.t1 VNW.t2 324.325
R24 VNW.t4 VNW.t5 324.325
R25 VNW VNW.t0 308.88
R26 VPW.t5 VPW.t1 3383.56
R27 VPW.t2 VPW.t3 2448.63
R28 VPW.t0 VPW.t4 1662.1
R29 VPW VPW.t0 1268.84
R30 VPW.t1 VPW.t2 1246.58
R31 VPW.t4 VPW.t5 1246.58
C0 VSS I 0.15704f
C1 VSS a_523_68# 0.00306f
C2 VNW a_671_644# 0.48041f
C3 a_895_68# VSS 0.30438f
C4 Z VSS 0.04629f
C5 a_895_68# a_1147_68# 0.00184f
C6 Z a_1147_68# 0
C7 VSS VDD 0.01202f
C8 a_671_644# a_47_68# 0.10782f
C9 I a_523_68# 0.00145f
C10 a_895_68# I 0
C11 a_503_644# VDD 0.0043f
C12 Z I 0
C13 Z a_523_68# 0
C14 Z a_895_68# 0.20995f
C15 VNW VSS 0.01061f
C16 I VDD 0.02961f
C17 a_895_68# VDD 0.12277f
C18 Z VDD 0.13718f
C19 a_47_68# VSS 0.11439f
C20 a_895_68# a_1127_622# 0.00209f
C21 VNW I 0.23093f
C22 Z a_1127_622# 0
C23 VNW a_895_68# 0.1955f
C24 a_503_644# a_47_68# 0.00165f
C25 a_47_68# a_1147_68# 0
C26 VNW Z 0.05449f
C27 a_671_644# VSS 0.10957f
C28 a_1127_622# VDD 0.00419f
C29 a_47_68# I 0.45257f
C30 VNW VDD 0.23977f
C31 a_47_68# a_523_68# 0
C32 a_895_68# a_47_68# 0.00337f
C33 Z a_47_68# 0
C34 a_671_644# I 0.05468f
C35 a_671_644# a_895_68# 0.54229f
C36 a_47_68# VDD 0.19236f
C37 a_671_644# Z 0.01419f
C38 VNW a_47_68# 0.49981f
C39 a_1147_68# VSS 0.00322f
C40 a_671_644# VDD 0.09605f
C41 VSS VPW 0.71227f
C42 Z VPW 0.20935f
C43 VDD VPW 0.51138f
C44 I VPW 0.63732f
C45 VNW VPW 3.25685f
C46 a_895_68# VPW 0.23227f
C47 a_671_644# VPW 0.46364f
C48 a_47_68# VPW 0.50427f
C49 VNW.t3 VPW 0.40784f
C50 VNW.t2 VPW 0.21699f
C51 VNW.t1 VPW 0.27189f
C52 VNW.t5 VPW 0.27189f
C53 VNW.t4 VPW 0.1708f
C54 VNW.t0 VPW 0.16732f
C55 I.t1 VPW 0.18481f
C56 I.t0 VPW 0.09131f
C57 I.n0 VPW 0.27897f
C58 VDD.t3 VPW 0.0082f
C59 VDD.t2 VPW 0.00592f
C60 VDD.n0 VPW 0.01423f
C61 VDD.t1 VPW 0.06477f
C62 VDD.t0 VPW 0.00592f
C63 VDD.n1 VPW 0.07342f
C64 VDD.n2 VPW 0.54977f
C65 Z.t0 VPW 0.08681f
C66 Z.t1 VPW 0.0689f
C67 Z.n0 VPW 0.19552f
C68 VSS.t2 VPW 0.00562f
C69 VSS.t3 VPW 0.00562f
C70 VSS.n0 VPW 0.01133f
C71 VSS.t1 VPW 0.03909f
C72 VSS.t0 VPW 0.0057f
C73 VSS.n1 VPW 0.06018f
C74 VSS.n2 VPW 0.51933f
.ends

.subckt gf180mcu_fd_sc_mcu7t5v0__fillcap_32 VDD VSS VNW VPW a_1916_375# a_1380_472#
+ a_3260_375# a_36_472# a_932_472# a_2812_375# a_2276_472# a_1828_472# a_3172_472#
+ a_572_375# a_2724_472# a_124_375# a_1468_375# a_1020_375# a_484_472# a_2364_375#
X0 VDD.t6 a_572_375# a_484_472# VNW.t6 pfet_05v0 ad=0.5368p pd=3.32u as=0.5368p ps=3.32u w=1.22u l=1u
X1 VDD.t0 a_2364_375# a_2276_472# VNW.t0 pfet_05v0 ad=0.5368p pd=3.32u as=0.5368p ps=3.32u w=1.22u l=1u
X2 a_572_375# a_484_472# VSS.t6 VPW.t6 nfet_05v0 ad=0.3608p pd=2.52u as=0.3608p ps=2.52u w=0.82u l=1u
X3 VDD.t4 a_1916_375# a_1828_472# VNW.t4 pfet_05v0 ad=0.5368p pd=3.32u as=0.5368p ps=3.32u w=1.22u l=1u
X4 a_124_375# a_36_472# VSS.t4 VPW.t4 nfet_05v0 ad=0.3608p pd=2.52u as=0.3608p ps=2.52u w=0.82u l=1u
X5 a_1916_375# a_1828_472# VSS.t3 VPW.t3 nfet_05v0 ad=0.3608p pd=2.52u as=0.3608p ps=2.52u w=0.82u l=1u
X6 a_1468_375# a_1380_472# VSS.t5 VPW.t5 nfet_05v0 ad=0.3608p pd=2.52u as=0.3608p ps=2.52u w=0.82u l=1u
X7 a_2812_375# a_2724_472# VSS.t7 VPW.t7 nfet_05v0 ad=0.3608p pd=2.52u as=0.3608p ps=2.52u w=0.82u l=1u
X8 VDD.t7 a_3260_375# a_3172_472# VNW.t7 pfet_05v0 ad=0.5368p pd=3.32u as=0.5368p ps=3.32u w=1.22u l=1u
X9 a_2364_375# a_2276_472# VSS.t1 VPW.t1 nfet_05v0 ad=0.3608p pd=2.52u as=0.3608p ps=2.52u w=0.82u l=1u
X10 VDD.t5 a_2812_375# a_2724_472# VNW.t5 pfet_05v0 ad=0.5368p pd=3.32u as=0.5368p ps=3.32u w=1.22u l=1u
X11 a_3260_375# a_3172_472# VSS.t0 VPW.t0 nfet_05v0 ad=0.3608p pd=2.52u as=0.3608p ps=2.52u w=0.82u l=1u
X12 VDD.t3 a_1020_375# a_932_472# VNW.t3 pfet_05v0 ad=0.5368p pd=3.32u as=0.5368p ps=3.32u w=1.22u l=1u
X13 VDD.t1 a_1468_375# a_1380_472# VNW.t1 pfet_05v0 ad=0.5368p pd=3.32u as=0.5368p ps=3.32u w=1.22u l=1u
X14 VDD.t2 a_124_375# a_36_472# VNW.t2 pfet_05v0 ad=0.5368p pd=3.32u as=0.5368p ps=3.32u w=1.22u l=1u
X15 a_1020_375# a_932_472# VSS.t2 VPW.t2 nfet_05v0 ad=0.3608p pd=2.52u as=0.3608p ps=2.52u w=0.82u l=1u
R0 VSS.n0 VSS.t0 8.84732
R1 VSS.n3 VSS.t4 8.84732
R2 VSS.n0 VSS.t7 8.51132
R3 VSS.n1 VSS.t1 8.51132
R4 VSS.n2 VSS.t3 8.51132
R5 VSS.n5 VSS.t5 8.51132
R6 VSS.n4 VSS.t2 8.51132
R7 VSS.n3 VSS.t6 8.51132
R8 VSS.n1 VSS.n0 0.3365
R9 VSS.n2 VSS.n1 0.3365
R10 VSS.n5 VSS.n4 0.3365
R11 VSS.n4 VSS.n3 0.3365
R12 VSS VSS.n5 0.28175
R13 VSS VSS.n2 0.05525
R14 VDD.n3 VDD.t2 4.69635
R15 VDD.n0 VDD.t7 4.69635
R16 VDD.n3 VDD.t6 4.36035
R17 VDD.n4 VDD.t3 4.36035
R18 VDD.n5 VDD.t1 4.36035
R19 VDD.n2 VDD.t4 4.36035
R20 VDD.n1 VDD.t0 4.36035
R21 VDD.n0 VDD.t5 4.36035
R22 VDD.n1 VDD.n0 0.3365
R23 VDD.n2 VDD.n1 0.3365
R24 VDD.n5 VDD.n4 0.3365
R25 VDD.n4 VDD.n3 0.3365
R26 VDD VDD.n2 0.28775
R27 VDD VDD.n5 0.04925
R28 VNW.t5 VNW.t7 864.865
R29 VNW.t0 VNW.t5 864.865
R30 VNW.t4 VNW.t0 864.865
R31 VNW.t1 VNW.t4 864.865
R32 VNW.t3 VNW.t1 864.865
R33 VNW.t6 VNW.t3 864.865
R34 VNW.t2 VNW.t6 864.865
R35 VNW VNW.t2 299.228
R36 VPW.t7 VPW.t0 3324.2
R37 VPW.t1 VPW.t7 3324.2
R38 VPW.t3 VPW.t1 3324.2
R39 VPW.t5 VPW.t3 3324.2
R40 VPW.t2 VPW.t5 3324.2
R41 VPW.t6 VPW.t2 3324.2
R42 VPW.t4 VPW.t6 3324.2
R43 VPW VPW.t4 1157.53
C0 a_484_472# a_932_472# 0.01328f
C1 VSS a_1916_375# 0.13306f
C2 VSS a_932_472# 0.14764f
C3 VNW a_2724_472# 0.0423f
C4 a_2364_375# a_1916_375# 0.0131f
C5 VNW a_1020_375# 0.19577f
C6 VDD a_3172_472# 0.1835f
C7 VSS a_2724_472# 0.14764f
C8 VSS a_1020_375# 0.13306f
C9 VDD a_2812_375# 0.14492f
C10 a_2724_472# a_2364_375# 0.08717f
C11 VDD a_124_375# 0.14169f
C12 VNW a_3260_375# 0.19553f
C13 VNW a_572_375# 0.19577f
C14 a_1468_375# a_1828_472# 0.08717f
C15 VDD a_36_472# 0.09598f
C16 VSS a_3260_375# 0.08206f
C17 a_484_472# a_572_375# 0.30831f
C18 VSS a_572_375# 0.13306f
C19 a_2724_472# a_3172_472# 0.01328f
C20 VNW a_1828_472# 0.0423f
C21 VDD a_1380_472# 0.1835f
C22 a_1468_375# VNW 0.19577f
C23 a_2724_472# a_2812_375# 0.30831f
C24 a_1380_472# a_932_472# 0.01328f
C25 VSS a_1828_472# 0.14764f
C26 VDD a_2276_472# 0.1835f
C27 a_1468_375# VSS 0.13306f
C28 a_2276_472# a_1916_375# 0.08717f
C29 a_3172_472# a_3260_375# 0.30831f
C30 VNW a_484_472# 0.0423f
C31 VNW VSS 0.03529f
C32 a_2812_375# a_3260_375# 0.0131f
C33 a_1380_472# a_1020_375# 0.08717f
C34 a_572_375# a_124_375# 0.0131f
C35 VNW a_2364_375# 0.19577f
C36 VDD a_1916_375# 0.14492f
C37 VDD a_932_472# 0.1835f
C38 VSS a_484_472# 0.14764f
C39 a_2724_472# a_2276_472# 0.01328f
C40 VSS a_2364_375# 0.13306f
C41 VDD a_2724_472# 0.1835f
C42 VNW a_3172_472# 0.04268f
C43 VDD a_1020_375# 0.14492f
C44 VNW a_2812_375# 0.19577f
C45 VNW a_124_375# 0.19448f
C46 a_932_472# a_1020_375# 0.30831f
C47 a_1380_472# a_1828_472# 0.01328f
C48 VSS a_3172_472# 0.1444f
C49 a_1468_375# a_1380_472# 0.30831f
C50 a_484_472# a_124_375# 0.08717f
C51 VSS a_2812_375# 0.13306f
C52 VSS a_124_375# 0.13306f
C53 VDD a_3260_375# 0.14423f
C54 VNW a_36_472# 0.0456f
C55 a_2364_375# a_2812_375# 0.0131f
C56 a_1828_472# a_2276_472# 0.01328f
C57 VDD a_572_375# 0.14492f
C58 VNW a_1380_472# 0.0423f
C59 a_484_472# a_36_472# 0.01328f
C60 VSS a_36_472# 0.14694f
C61 a_932_472# a_572_375# 0.08717f
C62 VNW a_2276_472# 0.0423f
C63 VSS a_1380_472# 0.14764f
C64 VDD a_1828_472# 0.1835f
C65 a_1468_375# VDD 0.14492f
C66 a_3172_472# a_2812_375# 0.08717f
C67 a_1828_472# a_1916_375# 0.30831f
C68 a_1468_375# a_1916_375# 0.0131f
C69 VSS a_2276_472# 0.14764f
C70 VNW VDD 0.55778f
C71 a_572_375# a_1020_375# 0.0131f
C72 a_2276_472# a_2364_375# 0.30831f
C73 VNW a_1916_375# 0.19577f
C74 VDD a_484_472# 0.1835f
C75 VNW a_932_472# 0.0423f
C76 VDD VSS 0.05274f
C77 a_124_375# a_36_472# 0.30831f
C78 a_1468_375# a_1020_375# 0.0131f
C79 VDD a_2364_375# 0.14492f
C80 VSS VPW 1.27478f
C81 VDD VPW 0.89875f
C82 VNW VPW 5.99156f
C83 a_3172_472# VPW 0.21516f
C84 a_2724_472# VPW 0.20251f
C85 a_2276_472# VPW 0.20251f
C86 a_1828_472# VPW 0.20251f
C87 a_1380_472# VPW 0.20251f
C88 a_932_472# VPW 0.20251f
C89 a_484_472# VPW 0.20251f
C90 a_36_472# VPW 0.27314f
C91 a_3260_375# VPW 0.11275f
C92 a_2812_375# VPW 0.05112f
C93 a_2364_375# VPW 0.05112f
C94 a_1916_375# VPW 0.05112f
C95 a_1468_375# VPW 0.05112f
C96 a_1020_375# VPW 0.05112f
C97 a_572_375# VPW 0.05112f
C98 a_124_375# VPW 0.06537f
C99 VNW.t7 VPW 0.3554f
C100 VNW.t5 VPW 0.29817f
C101 VNW.t0 VPW 0.29817f
C102 VNW.t4 VPW 0.29817f
C103 VNW.t1 VPW 0.29817f
C104 VNW.t3 VPW 0.29817f
C105 VNW.t6 VPW 0.29817f
C106 VNW.t2 VPW 0.20066f
C107 VDD.t4 VPW 0.0769f
C108 VDD.t0 VPW 0.0769f
C109 VDD.t5 VPW 0.0769f
C110 VDD.t7 VPW 0.09354f
C111 VDD.n0 VPW 0.5324f
C112 VDD.n1 VPW 0.31641f
C113 VDD.n2 VPW 0.2985f
C114 VDD.t1 VPW 0.0769f
C115 VDD.t3 VPW 0.0769f
C116 VDD.t6 VPW 0.0769f
C117 VDD.t2 VPW 0.10553f
C118 VDD.n3 VPW 0.68797f
C119 VDD.n4 VPW 0.31641f
C120 VDD.n5 VPW 0.21086f
C121 VSS.t3 VPW 0.04613f
C122 VSS.t1 VPW 0.04613f
C123 VSS.t7 VPW 0.04613f
C124 VSS.t0 VPW 0.05783f
C125 VSS.n0 VPW 0.53494f
C126 VSS.n1 VPW 0.2387f
C127 VSS.n2 VPW 0.15331f
C128 VSS.t5 VPW 0.04613f
C129 VSS.t2 VPW 0.04613f
C130 VSS.t6 VPW 0.04613f
C131 VSS.t4 VPW 0.05257f
C132 VSS.n3 VPW 0.40174f
C133 VSS.n4 VPW 0.2387f
C134 VSS.n5 VPW 0.22208f
.ends

.subckt gf180mcu_fd_sc_mcu7t5v0__fillcap_16 VDD VSS VNW VPW a_1380_472# a_36_472#
+ a_932_472# a_572_375# a_124_375# a_1468_375# a_1020_375# a_484_472#
X0 VDD.t2 a_572_375# a_484_472# VNW.t2 pfet_05v0 ad=0.5368p pd=3.32u as=0.5368p ps=3.32u w=1.22u l=1u
X1 a_572_375# a_484_472# VSS.t2 VPW.t2 nfet_05v0 ad=0.3608p pd=2.52u as=0.3608p ps=2.52u w=0.82u l=1u
X2 a_124_375# a_36_472# VSS.t1 VPW.t1 nfet_05v0 ad=0.3608p pd=2.52u as=0.3608p ps=2.52u w=0.82u l=1u
X3 a_1468_375# a_1380_472# VSS.t3 VPW.t3 nfet_05v0 ad=0.3608p pd=2.52u as=0.3608p ps=2.52u w=0.82u l=1u
X4 VDD.t3 a_1020_375# a_932_472# VNW.t3 pfet_05v0 ad=0.5368p pd=3.32u as=0.5368p ps=3.32u w=1.22u l=1u
X5 VDD.t0 a_1468_375# a_1380_472# VNW.t0 pfet_05v0 ad=0.5368p pd=3.32u as=0.5368p ps=3.32u w=1.22u l=1u
X6 VDD.t1 a_124_375# a_36_472# VNW.t1 pfet_05v0 ad=0.5368p pd=3.32u as=0.5368p ps=3.32u w=1.22u l=1u
X7 a_1020_375# a_932_472# VSS.t0 VPW.t0 nfet_05v0 ad=0.3608p pd=2.52u as=0.3608p ps=2.52u w=0.82u l=1u
R0 VSS.n0 VSS.t3 8.84732
R1 VSS.n1 VSS.t1 8.84732
R2 VSS.n0 VSS.t0 8.51132
R3 VSS.n1 VSS.t2 8.51132
R4 VSS VSS.n1 0.2825
R5 VSS VSS.n0 0.0545
R6 VDD.n1 VDD.t1 4.69635
R7 VDD.n0 VDD.t0 4.69635
R8 VDD.n1 VDD.t2 4.36035
R9 VDD.n0 VDD.t3 4.36035
R10 VDD VDD.n0 0.2825
R11 VDD VDD.n1 0.0545
R12 VNW.t3 VNW.t0 864.865
R13 VNW.t2 VNW.t3 864.865
R14 VNW.t1 VNW.t2 864.865
R15 VNW VNW.t1 299.228
R16 VPW.t0 VPW.t3 3324.2
R17 VPW.t2 VPW.t0 3324.2
R18 VPW.t1 VPW.t2 3324.2
R19 VPW VPW.t1 1157.53
C0 a_1020_375# VNW 0.19577f
C1 a_1380_472# a_1020_375# 0.0869f
C2 VSS a_36_472# 0.1523f
C3 VSS a_932_472# 0.15299f
C4 VSS a_1468_375# 0.08285f
C5 a_1020_375# a_932_472# 0.30831f
C6 VSS a_1020_375# 0.13603f
C7 a_1020_375# a_1468_375# 0.01255f
C8 a_124_375# VDD 0.14169f
C9 a_484_472# a_124_375# 0.0869f
C10 a_572_375# a_124_375# 0.01255f
C11 a_484_472# VDD 0.1835f
C12 VNW a_124_375# 0.19448f
C13 a_572_375# VDD 0.14492f
C14 a_484_472# a_572_375# 0.30831f
C15 VNW VDD 0.28421f
C16 a_484_472# VNW 0.0423f
C17 a_1380_472# VDD 0.1835f
C18 a_572_375# VNW 0.19577f
C19 a_124_375# a_36_472# 0.30831f
C20 VSS a_124_375# 0.13603f
C21 a_1380_472# VNW 0.04268f
C22 VDD a_36_472# 0.09598f
C23 VDD a_932_472# 0.1835f
C24 VSS VDD 0.02637f
C25 a_484_472# a_36_472# 0.01328f
C26 a_484_472# a_932_472# 0.01328f
C27 a_484_472# VSS 0.15299f
C28 VDD a_1468_375# 0.14423f
C29 a_572_375# a_932_472# 0.0869f
C30 a_572_375# VSS 0.13603f
C31 VNW a_36_472# 0.0456f
C32 a_1020_375# VDD 0.14492f
C33 VNW a_932_472# 0.0423f
C34 VSS VNW 0.01764f
C35 VNW a_1468_375# 0.19553f
C36 a_1380_472# a_932_472# 0.01328f
C37 a_1380_472# VSS 0.14976f
C38 a_572_375# a_1020_375# 0.01255f
C39 a_1380_472# a_1468_375# 0.30831f
C40 VSS VPW 0.72778f
C41 VDD VPW 0.54672f
C42 VNW VPW 3.20078f
C43 a_1380_472# VPW 0.21516f
C44 a_932_472# VPW 0.20251f
C45 a_484_472# VPW 0.20251f
C46 a_36_472# VPW 0.27314f
C47 a_1468_375# VPW 0.11269f
C48 a_1020_375# VPW 0.05106f
C49 a_572_375# VPW 0.05106f
C50 a_124_375# VPW 0.06485f
C51 VNW.t0 VPW 0.34158f
C52 VNW.t3 VPW 0.28657f
C53 VNW.t2 VPW 0.28657f
C54 VNW.t1 VPW 0.19286f
C55 VDD.t3 VPW 0.07492f
C56 VDD.t0 VPW 0.09114f
C57 VDD.n0 VPW 0.49939f
C58 VDD.t2 VPW 0.07492f
C59 VDD.t1 VPW 0.10282f
C60 VDD.n1 VPW 0.56934f
C61 VSS.t0 VPW 0.04616f
C62 VSS.t3 VPW 0.05789f
C63 VSS.n0 VPW 0.45104f
C64 VSS.t2 VPW 0.04616f
C65 VSS.t1 VPW 0.05263f
C66 VSS.n1 VPW 0.38706f
.ends

.subckt gf180mcu_fd_sc_mcu7t5v0__nand3_1 A3 VDD VSS ZN A1 A2 VNW VPW a_455_68# a_271_68#
X0 ZN.t0 A1.t0 a_455_68# VPW.t1 nfet_05v0 ad=0.3608p pd=2.52u as=0.1722p ps=1.24u w=0.82u l=0.6u
X1 ZN.t3 A3.t1 VDD.t2 VNW.t2 pfet_05v0 ad=0.2561p pd=1.505u as=0.4334p ps=2.85u w=0.985u l=0.5u
X2 VDD.t0 A2.t1 ZN.t1 VNW.t0 pfet_05v0 ad=0.2561p pd=1.505u as=0.2561p ps=1.505u w=0.985u l=0.5u
X3 ZN.t2 A1.t1 VDD.t1 VNW.t1 pfet_05v0 ad=0.4334p pd=2.85u as=0.2561p ps=1.505u w=0.985u l=0.5u
X4 a_271_68# A3.t0 VSS.t0 VPW.t2 nfet_05v0 ad=0.1312p pd=1.14u as=0.3608p ps=2.52u w=0.82u l=0.6u
X5 a_455_68# A2.t0 a_271_68# VPW.t0 nfet_05v0 ad=0.1722p pd=1.24u as=0.1312p ps=1.14u w=0.82u l=0.6u
R0 VSS VSS.t0 8.63325
R1 ZN.n0 ZN.t0 8.84645
R2 ZN.n0 ZN.t2 4.50873
R3 ZN ZN.n1 2.89216
R4 ZN.n1 ZN.t1 1.84822
R5 ZN.n1 ZN.t3 1.84822
R6 ZN ZN.n0 0.215857
R7 VDD VDD.n0 5.38601
R8 VDD VDD.t2 4.92036
R9 VDD.n0 VDD.t1 1.84822
R10 VDD.n0 VDD.t0 1.84822
R11 A1.n0 A1.t1 18.6155
R12 A1.n0 A1.t0 11.8752
R13 A1 A1.n0 8.07453
R14 A2.n0 A2.t1 18.6155
R15 A2.n0 A2.t0 11.8752
R16 A2 A2.n0 8.06425
R17 A3.n0 A3.t0 15.4522
R18 A3.n0 A3.t1 15.0385
R19 A3 A3.n0 8.11161
R20 VNW.t0 VNW.t1 393.822
R21 VNW.t2 VNW.t0 393.822
R22 VNW VNW.t2 254.827
R23 VPW.t0 VPW.t1 1513.7
R24 VPW.t2 VPW.t0 1365.3
R25 VPW VPW.t2 1061.07
C0 ZN A2 0.08568f
C1 A1 VSS 0.08509f
C2 A1 VNW 0.12917f
C3 A3 A2 0.11757f
C4 VSS a_271_68# 0.0071f
C5 ZN A3 0.01751f
C6 A1 A2 0.13304f
C7 A1 ZN 0.3869f
C8 a_271_68# A2 0.00403f
C9 ZN a_271_68# 0.00192f
C10 A1 A3 0
C11 A3 a_271_68# 0
C12 VDD VNW 0.12911f
C13 VDD VSS 0.00873f
C14 a_455_68# VSS 0.00711f
C15 VDD A2 0.02318f
C16 VDD ZN 0.33798f
C17 a_455_68# A2 0.00513f
C18 ZN a_455_68# 0.00293f
C19 VDD A3 0.08911f
C20 A1 VDD 0.02202f
C21 VNW VSS 0.00858f
C22 VDD a_271_68# 0
C23 A1 a_455_68# 0.00498f
C24 VSS A2 0.10556f
C25 VNW A2 0.12119f
C26 ZN VSS 0.06413f
C27 VNW ZN 0.05761f
C28 VSS A3 0.0815f
C29 VNW A3 0.14824f
C30 VSS VPW 0.62897f
C31 ZN VPW 0.36259f
C32 VDD VPW 0.68694f
C33 A1 VPW 0.3556f
C34 A2 VPW 0.30295f
C35 A3 VPW 0.27977f
C36 VNW VPW 1.62291f
C37 VNW.t1 VPW 0.22551f
C38 VNW.t0 VPW 0.12673f
C39 VNW.t2 VPW 0.10437f
C40 A3.t1 VPW 0.1094f
C41 A3.t0 VPW 0.12893f
C42 A3.n0 VPW 0.15229f
C43 A2.t1 VPW 0.14162f
C44 A2.t0 VPW 0.12288f
C45 A2.n0 VPW 0.1737f
C46 A1.t1 VPW 0.18812f
C47 A1.t0 VPW 0.16322f
C48 A1.n0 VPW 0.23073f
C49 VDD.t1 VPW 0.02104f
C50 VDD.t0 VPW 0.02104f
C51 VDD.n0 VPW 0.04546f
C52 VDD.t2 VPW 0.06109f
C53 ZN.t2 VPW 0.09991f
C54 ZN.t0 VPW 0.10242f
C55 ZN.n0 VPW 0.32341f
C56 ZN.t1 VPW 0.04124f
C57 ZN.t3 VPW 0.04124f
C58 ZN.n1 VPW 0.093f
C59 VSS.t0 VPW 0.04223f
.ends

.subckt gf180mcu_fd_sc_mcu7t5v0__xor2_1 VDD VSS Z A1 A2 VNW VPW a_952_68# a_728_472#
+ a_244_604# a_56_604#
X0 a_728_472# a_56_604# VDD.t1 VNW.t2 pfet_05v0 ad=0.3172p pd=1.74u as=0.4005p ps=2.12u w=1.22u l=0.5u
X1 Z.t0 A1.t2 a_728_472# VNW.t4 pfet_05v0 ad=0.3172p pd=1.74u as=0.3172p ps=1.74u w=1.22u l=0.5u
X2 VSS.t3 A1.t1 a_56_604# VPW.t3 nfet_05v0 ad=0.218p pd=1.52u as=93.59999f ps=0.88u w=0.36u l=0.6u
X3 a_728_472# A2.t2 Z.t2 VNW.t1 pfet_05v0 ad=0.5368p pd=3.32u as=0.3172p ps=1.74u w=1.22u l=0.5u
X4 Z.t1 a_56_604# VSS.t2 VPW.t2 nfet_05v0 ad=0.2132p pd=1.34u as=0.218p ps=1.52u w=0.82u l=0.6u
X5 VSS.t1 A2.t0 a_952_68# VPW.t1 nfet_05v0 ad=0.3608p pd=2.52u as=0.1312p ps=1.14u w=0.82u l=0.6u
X6 a_244_604# A2.t3 a_56_604# VNW.t0 pfet_05v0 ad=0.1456p pd=1.08u as=0.2464p ps=2u w=0.56u l=0.5u
X7 a_56_604# A2.t1 VSS.t0 VPW.t0 nfet_05v0 ad=93.59999f pd=0.88u as=0.1584p ps=1.6u w=0.36u l=0.6u
X8 a_952_68# A1.t0 Z.t3 VPW.t4 nfet_05v0 ad=0.1312p pd=1.14u as=0.2132p ps=1.34u w=0.82u l=0.6u
X9 VDD.t0 A1.t3 a_244_604# VNW.t3 pfet_05v0 ad=0.4005p pd=2.12u as=0.1456p ps=1.08u w=0.56u l=0.5u
R0 VSS.n1 VSS.t0 11.3048
R1 VSS VSS.t1 8.7433
R2 VSS.n1 VSS.n0 6.39182
R3 VSS.n0 VSS.t3 6.32611
R4 VSS.n0 VSS.t2 1.99806
R5 VSS VSS.n1 0.0875
R6 Z Z.n1 7.16957
R7 Z Z.n0 5.91011
R8 Z.n1 Z.t3 1.99806
R9 Z.n1 Z.t1 1.99806
R10 Z.n0 Z.t2 1.4923
R11 Z.n0 Z.t0 1.4923
R12 VDD.n0 VDD.t0 8.0005
R13 VDD VDD.n0 2.79294
R14 VDD.n0 VDD.t1 1.72898
R15 A1.n0 A1.t2 22.1195
R16 A1.n1 A1.t3 19.5645
R17 A1.n1 A1.t1 18.4938
R18 A1.n0 A1.t0 9.02817
R19 A1 A1.n1 8.51318
R20 A1 A1.n0 8.35407
R21 A2.n1 A2.t3 19.5645
R22 A2.n1 A2.t1 18.4938
R23 A2.n0 A2.t0 16.7662
R24 A2.n0 A2.t2 14.3815
R25 A2 A2.n0 9.19631
R26 A2 A2.n1 8.16594
R27 VNW.t3 VNW.t2 540.542
R28 VNW.t4 VNW.t1 393.822
R29 VNW.t2 VNW.t4 393.822
R30 VNW.t0 VNW.t3 393.822
R31 VNW VNW.t0 241.314
R32 VPW.t3 VPW.t2 1929.22
R33 VPW.t2 VPW.t4 1662.1
R34 VPW.t0 VPW.t3 1662.1
R35 VPW.t4 VPW.t1 1365.3
R36 VPW VPW.t0 860.731
C0 a_56_604# VSS 0.42232f
C1 a_952_68# Z 0.00863f
C2 a_728_472# A2 0.10235f
C3 VSS a_728_472# 0.00189f
C4 VDD A2 0.23578f
C5 Z VNW 0.02819f
C6 a_56_604# a_728_472# 0.00488f
C7 A1 A2 0.85465f
C8 VSS VDD 0.01126f
C9 VSS A1 0.05563f
C10 a_56_604# VDD 0.11511f
C11 a_56_604# A1 0.35008f
C12 a_952_68# A2 0
C13 VDD a_728_472# 0.59813f
C14 VSS a_952_68# 0.00526f
C15 a_728_472# A1 0.01895f
C16 VNW A2 0.36255f
C17 a_56_604# a_952_68# 0
C18 VSS VNW 0.00951f
C19 VDD A1 0.04523f
C20 a_56_604# VNW 0.15024f
C21 Z A2 0.29991f
C22 a_728_472# VNW 0.00606f
C23 a_244_604# A2 0.00522f
C24 VSS Z 0.2761f
C25 VDD VNW 0.15701f
C26 a_56_604# Z 0.04115f
C27 a_56_604# a_244_604# 0.00257f
C28 A1 VNW 0.32646f
C29 Z a_728_472# 0.31393f
C30 Z VDD 0.00766f
C31 VDD a_244_604# 0.00914f
C32 VSS A2 0.05191f
C33 Z A1 0.2205f
C34 a_56_604# A2 0.39491f
C35 VSS VPW 0.83235f
C36 Z VPW 0.72792f
C37 VDD VPW 1.28579f
C38 A1 VPW 0.75894f
C39 A2 VPW 1.2975f
C40 VNW VPW 2.50507f
C41 a_728_472# VPW 0.00642f
C42 a_56_604# VPW 0.27721f
C43 VNW.t1 VPW 0.30597f
C44 VNW.t4 VPW 0.13995f
C45 VNW.t2 VPW 0.16602f
C46 VNW.t3 VPW 0.16602f
C47 VNW.t0 VPW 0.11285f
C48 A2.t2 VPW 0.21002f
C49 A2.t0 VPW 0.23097f
C50 A2.n0 VPW 0.30399f
C51 A2.t3 VPW 0.17373f
C52 A2.t1 VPW 0.16643f
C53 A2.n1 VPW 0.31937f
C54 A1.t2 VPW 0.2916f
C55 A1.t0 VPW 0.16965f
C56 A1.n0 VPW 0.29562f
C57 A1.t3 VPW 0.1855f
C58 A1.t1 VPW 0.17771f
C59 A1.n1 VPW 0.34313f
C60 VDD.t1 VPW 0.04889f
C61 VDD.t0 VPW 0.04131f
C62 VDD.n0 VPW 0.10931f
C63 Z.t2 VPW 0.07668f
C64 Z.t0 VPW 0.07668f
C65 Z.n0 VPW 0.17246f
C66 Z.t3 VPW 0.05154f
C67 Z.t1 VPW 0.05154f
C68 Z.n1 VPW 0.12331f
C69 VSS.t1 VPW 0.05595f
C70 VSS.t2 VPW 0.01642f
C71 VSS.t3 VPW 0.01124f
C72 VSS.n0 VPW 0.03972f
C73 VSS.t0 VPW 0.02303f
C74 VSS.n1 VPW 0.33305f
.ends

.subckt gf180mcu_fd_sc_mcu7t5v0__dffq_1 VDD Q CLK VSS D VNW VPW a_2011_527# a_448_472#
+ a_880_527# a_36_151# a_2304_115# a_2256_159# a_1328_159# a_2296_527# a_1348_527#
+ a_1004_159# a_1376_115# a_836_159#
X0 VSS.t0 CLK.t0 a_36_151# VPW.t8 nfet_05v0 ad=0.1053p pd=0.925u as=0.1782p ps=1.69u w=0.405u l=0.6u
X1 Q.t0 a_2304_115# VSS.t6 VPW.t11 nfet_05v0 ad=0.3608p pd=2.52u as=0.3608p ps=2.52u w=0.82u l=0.6u
X2 a_2304_115# a_2011_527# VSS.t5 VPW.t9 nfet_05v0 ad=0.176p pd=1.68u as=0.142p ps=1.14u w=0.4u l=0.6u
X3 a_1004_159# D.t0 a_836_159# VPW.t3 nfet_05v0 ad=0.207p pd=1.51u as=43.2f ps=0.6u w=0.36u l=0.6u
X4 a_1004_159# D.t1 a_880_527# VNW.t3 pfet_05v0 ad=0.1872p pd=1.4u as=54f ps=0.66u w=0.36u l=0.5u
X5 a_2011_527# a_36_151# a_1376_115# VNW.t6 pfet_05v0 ad=0.1665p pd=1.285u as=0.1791p ps=1.355u w=0.36u l=0.5u
X6 a_2296_527# a_448_472# a_2011_527# VNW.t2 pfet_05v0 ad=50.4f pd=0.64u as=0.1665p ps=1.285u w=0.36u l=0.5u
X7 a_1376_115# a_1004_159# VDD.t3 VNW.t7 pfet_05v0 ad=0.1791p pd=1.355u as=0.1044p ps=0.94u w=0.36u l=0.5u
X8 VDD.t4 CLK.t1 a_36_151# VNW.t8 pfet_05v0 ad=0.2249p pd=1.385u as=0.3806p ps=2.61u w=0.865u l=0.5u
X9 VSS.t1 a_1376_115# a_1328_159# VPW.t0 nfet_05v0 ad=0.2637p pd=1.825u as=43.2f ps=0.6u w=0.36u l=0.6u
X10 a_2011_527# a_448_472# a_1376_115# VPW.t2 nfet_05v0 ad=93.59999f pd=0.88u as=93.59999f ps=0.88u w=0.36u l=0.6u
X11 a_448_472# a_36_151# VDD.t2 VNW.t4 pfet_05v0 ad=0.3806p pd=2.61u as=0.2249p ps=1.385u w=0.865u l=0.5u
X12 Q.t1 a_2304_115# VDD.t6 VNW.t11 pfet_05v0 ad=0.5368p pd=3.32u as=0.5368p ps=3.32u w=1.22u l=0.5u
X13 a_1376_115# a_1004_159# VSS.t4 VPW.t7 nfet_05v0 ad=93.59999f pd=0.88u as=0.2637p ps=1.825u w=0.36u l=0.6u
X14 VSS.t7 a_2304_115# a_2256_159# VPW.t10 nfet_05v0 ad=0.142p pd=1.14u as=43.2f ps=0.6u w=0.36u l=0.6u
X15 a_836_159# a_36_151# VSS.t3 VPW.t5 nfet_05v0 ad=43.2f pd=0.6u as=0.1584p ps=1.6u w=0.36u l=0.6u
X16 a_448_472# a_36_151# VSS.t2 VPW.t4 nfet_05v0 ad=0.1782p pd=1.69u as=0.1053p ps=0.925u w=0.405u l=0.6u
X17 a_2256_159# a_36_151# a_2011_527# VPW.t6 nfet_05v0 ad=43.2f pd=0.6u as=93.59999f ps=0.88u w=0.36u l=0.6u
X18 a_880_527# a_448_472# VDD.t1 VNW.t1 pfet_05v0 ad=54f pd=0.66u as=0.4554p ps=3.25u w=0.36u l=0.5u
X19 a_1348_527# a_36_151# a_1004_159# VNW.t5 pfet_05v0 ad=43.2f pd=0.6u as=0.1872p ps=1.4u w=0.36u l=0.5u
X20 a_1328_159# a_448_472# a_1004_159# VPW.t1 nfet_05v0 ad=43.2f pd=0.6u as=0.207p ps=1.51u w=0.36u l=0.6u
X21 VDD.t0 a_1376_115# a_1348_527# VNW.t0 pfet_05v0 ad=0.1044p pd=0.94u as=43.2f ps=0.6u w=0.36u l=0.5u
X22 VDD.t7 a_2304_115# a_2296_527# VNW.t10 pfet_05v0 ad=0.23p pd=1.54u as=50.4f ps=0.64u w=0.36u l=0.5u
X23 a_2304_115# a_2011_527# VDD.t5 VNW.t9 pfet_05v0 ad=0.352p pd=2.48u as=0.23p ps=1.54u w=0.8u l=0.5u
R0 Q Q.t0 8.69622
R1 Q Q.t1 6.72245
R2 VSS.n4 VSS.n1 12.033
R3 VSS.n5 VSS.t3 11.0292
R4 VSS.n3 VSS.t6 8.75341
R5 VSS.n1 VSS.t4 8.4005
R6 VSS.n1 VSS.t1 8.4005
R7 VSS.n2 VSS.t7 8.0855
R8 VSS.n3 VSS.n2 6.54898
R9 VSS.n6 VSS.n0 6.46859
R10 VSS.n2 VSS.t5 4.0955
R11 VSS.n0 VSS.t2 4.04494
R12 VSS.n0 VSS.t0 4.04494
R13 VSS.n4 VSS.n3 0.6965
R14 VSS.n5 VSS.n4 0.6965
R15 VSS.n6 VSS.n5 0.2765
R16 VSS VSS.n6 0.0125
R17 D.n0 D.t1 19.6418
R18 D D.n0 8.62301
R19 D.n0 D.t0 5.66793
R20 CLK.n0 CLK.t0 13.907
R21 CLK.n0 CLK.t1 12.0455
R22 CLK CLK.n0 8.01471
R23 VDD.n5 VDD.t1 21.6375
R24 VDD.n2 VDD.t7 7.40883
R25 VDD.n1 VDD.t0 6.22272
R26 VDD.n3 VDD.n2 5.49789
R27 VDD.n4 VDD.n1 5.41359
R28 VDD.n6 VDD.n0 5.35271
R29 VDD.n1 VDD.t3 5.05606
R30 VDD.n3 VDD.t6 4.55874
R31 VDD.n2 VDD.t5 2.2755
R32 VDD.n0 VDD.t2 2.10455
R33 VDD.n0 VDD.t4 2.10455
R34 VDD.n4 VDD.n3 0.7415
R35 VDD.n5 VDD.n4 0.6575
R36 VDD.n6 VDD.n5 0.2915
R37 VDD VDD.n6 0.0125
R38 VNW.t4 VNW.t1 833.977
R39 VNW.t9 VNW.t11 671.816
R40 VNW.t7 VNW.t6 577.221
R41 VNW.t6 VNW.t2 550.193
R42 VNW.t10 VNW.t9 478.764
R43 VNW.t0 VNW.t7 416.988
R44 VNW.t8 VNW.t4 393.822
R45 VNW.t2 VNW.t10 301.159
R46 VNW.t5 VNW.t0 285.714
R47 VNW.t1 VNW.n0 276.062
R48 VNW VNW.t8 241.314
R49 VNW.n0 VNW.t5 142.857
R50 VNW.n0 VNW.t3 28.8573
R51 VPW.t9 VPW.t11 2879
R52 VPW.t4 VPW.t5 2730.59
R53 VPW.t3 VPW.t1 2404.11
R54 VPW.t0 VPW.t7 2315.07
R55 VPW.t10 VPW.t9 1988.58
R56 VPW.t2 VPW.t6 1662.1
R57 VPW.t7 VPW.t2 1662.1
R58 VPW.t8 VPW.t4 1662.1
R59 VPW.t6 VPW.t10 1246.58
R60 VPW.t1 VPW.t0 1246.58
R61 VPW.t5 VPW.t3 1246.58
R62 VPW VPW.t8 860.731
C0 VDD a_880_527# 0
C1 a_1004_159# VSS 0.01386f
C2 VDD D 0.00349f
C3 VNW VSS 0.01078f
C4 Q a_2304_115# 0.17225f
C5 D VSS 0.00349f
C6 a_36_151# CLK 0.48569f
C7 VDD CLK 0.02031f
C8 a_1328_159# a_1376_115# 0
C9 a_2256_159# a_448_472# 0
C10 VDD Q 0.15434f
C11 CLK VSS 0.02194f
C12 a_2256_159# a_2011_527# 0.00232f
C13 VSS Q 0.10956f
C14 a_1328_159# VSS 0.00147f
C15 a_448_472# a_2296_527# 0
C16 a_2011_527# a_2296_527# 0.00277f
C17 a_36_151# a_1348_527# 0
C18 a_448_472# a_2011_527# 0.41635f
C19 VDD a_1348_527# 0.00246f
C20 a_448_472# a_1004_159# 0.83991f
C21 VNW a_448_472# 0.42529f
C22 a_36_151# a_836_159# 0
C23 a_448_472# a_880_527# 0
C24 a_1004_159# a_2011_527# 0
C25 a_448_472# D 0.24298f
C26 VNW a_2011_527# 0.24182f
C27 a_36_151# a_1376_115# 0.08109f
C28 a_36_151# a_2304_115# 0.03873f
C29 CLK a_448_472# 0.00119f
C30 VNW a_1004_159# 0.24039f
C31 VDD a_1376_115# 0.01976f
C32 a_1004_159# a_880_527# 0
C33 a_1004_159# D 0.20652f
C34 VDD a_2304_115# 0.17917f
C35 a_1376_115# VSS 0.14376f
C36 VNW D 0.179f
C37 D a_880_527# 0.00144f
C38 Q a_2011_527# 0
C39 VSS a_2304_115# 0.27806f
C40 a_36_151# VDD 1.20804f
C41 a_36_151# VSS 0.24119f
C42 VNW CLK 0.13328f
C43 a_1328_159# a_448_472# 0.00306f
C44 VDD VSS 0.00787f
C45 VNW Q 0.03696f
C46 a_2256_159# a_2304_115# 0
C47 a_2256_159# VSS 0.00239f
C48 a_448_472# a_1348_527# 0
C49 a_448_472# a_836_159# 0.00393f
C50 a_1004_159# a_1348_527# 0.00275f
C51 a_448_472# a_1376_115# 1.16478f
C52 a_448_472# a_2304_115# 0.02307f
C53 a_1376_115# a_2011_527# 0.02112f
C54 a_2011_527# a_2304_115# 0.49964f
C55 a_1004_159# a_836_159# 0
C56 VDD a_2296_527# 0.0029f
C57 a_36_151# a_448_472# 0.72261f
C58 a_36_151# a_2011_527# 0.04722f
C59 a_1376_115# a_1004_159# 0.10745f
C60 VNW a_1376_115# 0.167f
C61 VDD a_448_472# 0.68369f
C62 a_448_472# VSS 0.8973f
C63 VDD a_2011_527# 0.12733f
C64 a_1376_115# D 0.00472f
C65 VNW a_2304_115# 0.33869f
C66 VSS a_2011_527# 0.1119f
C67 a_36_151# a_1004_159# 0.22071f
C68 a_36_151# VNW 0.9698f
C69 a_36_151# a_880_527# 0.00384f
C70 a_36_151# D 0.1215f
C71 VDD a_1004_159# 0.16054f
C72 VNW VDD 0.48585f
C73 Q VPW 0.40389f
C74 VSS VPW 1.29225f
C75 D VPW 0.47919f
C76 CLK VPW 0.34361f
C77 VDD VPW 0.87766f
C78 VNW VPW 5.50193f
C79 a_2304_115# VPW 0.37835f
C80 a_2011_527# VPW 0.26006f
C81 a_1004_159# VPW 0.17588f
C82 a_1376_115# VPW 0.16786f
C83 a_448_472# VPW 0.3638f
C84 a_36_151# VPW 0.70439f
C85 VNW.t11 VPW 0.48321f
C86 VNW.t9 VPW 0.28235f
C87 VNW.t10 VPW 0.19139f
C88 VNW.t2 VPW 0.20892f
C89 VNW.t6 VPW 0.27666f
C90 VNW.t7 VPW 0.24397f
C91 VNW.t0 VPW 0.17244f
C92 VNW.t5 VPW 0.10517f
C93 VNW.t3 VPW 0.09111f
C94 VNW.n0 VPW 0.23802f
C95 VNW.t1 VPW 0.2724f
C96 VNW.t4 VPW 0.3013f
C97 VNW.t8 VPW 0.15586f
C98 VDD.t2 VPW 0.02652f
C99 VDD.t4 VPW 0.02652f
C100 VDD.n0 VPW 0.05397f
C101 VDD.t1 VPW 0.05828f
C102 VDD.t3 VPW 0.01104f
C103 VDD.t0 VPW 0.01359f
C104 VDD.n1 VPW 0.02626f
C105 VDD.t5 VPW 0.02453f
C106 VDD.t7 VPW 0.01906f
C107 VDD.n2 VPW 0.06669f
C108 VDD.t6 VPW 0.12356f
C109 VDD.n3 VPW 0.95305f
C110 VDD.n4 VPW 0.73165f
C111 VDD.n5 VPW 0.51995f
C112 VDD.n6 VPW 0.19736f
C113 CLK.t1 VPW 0.14558f
C114 CLK.t0 VPW 0.13546f
C115 CLK.n0 VPW 0.21452f
C116 D.t0 VPW 0.06134f
C117 D.t1 VPW 0.12728f
C118 D.n0 VPW 0.26192f
C119 VSS.t2 VPW 0.00794f
C120 VSS.t0 VPW 0.00794f
C121 VSS.n0 VPW 0.01645f
C122 VSS.t3 VPW 0.01732f
C123 VSS.t4 VPW 0.01303f
C124 VSS.t1 VPW 0.01303f
C125 VSS.n1 VPW 0.04472f
C126 VSS.t5 VPW 0.00784f
C127 VSS.t7 VPW 0.0129f
C128 VSS.n2 VPW 0.02272f
C129 VSS.t6 VPW 0.05461f
C130 VSS.n3 VPW 0.58673f
C131 VSS.n4 VPW 0.44314f
C132 VSS.n5 VPW 0.34019f
C133 VSS.n6 VPW 0.12473f
C134 Q.t1 VPW 0.0966f
C135 Q.t0 VPW 0.06809f
.ends

.subckt gf180mcu_fd_sc_mcu7t5v0__clkinv_1 VDD VSS I ZN VNW VPW
X0 ZN.t1 I.t0 VSS.t0 VPW.t0 nfet_05v0 ad=0.2112p pd=1.84u as=0.2112p ps=1.84u w=0.48u l=0.6u
X1 ZN.t0 I.t1 VDD.t0 VNW.t0 pfet_05v0 ad=0.5368p pd=3.32u as=0.5368p ps=3.32u w=1.22u l=0.5u
R0 VSS VSS.t0 10.092
R1 ZN ZN.t1 10.0058
R2 ZN ZN.t0 4.35156
R3 VDD VDD.t0 4.52026
R4 I.n0 I.t1 17.5205
R5 I.n0 I.t0 11.5588
R6 I I.n0 8.05312
R7 VNW VNW.t0 306.452
R8 VPW VPW.t0 1053.63
C0 VNW VSS 0.01109f
C1 VNW I 0.13721f
C2 I VSS 0.06221f
C3 VDD ZN 0.09877f
C4 VNW VDD 0.08761f
C5 VNW ZN 0.03118f
C6 VDD VSS 0.02544f
C7 ZN VSS 0.07714f
C8 I VDD 0.16229f
C9 I ZN 0.47009f
C10 VSS VPW 0.39773f
C11 ZN VPW 0.53242f
C12 VDD VPW 0.46622f
C13 I VPW 0.51983f
C14 VNW VPW 1.05681f
C15 VNW.t0 VPW 0.17376f
C16 I.t1 VPW 0.21428f
C17 I.t0 VPW 0.11654f
C18 I.n0 VPW 0.22324f
C19 VDD.t0 VPW 0.0786f
C20 ZN.t0 VPW 0.17199f
C21 ZN.t1 VPW 0.06806f
C22 VSS.t0 VPW 0.01774f
.ends

.subckt gf180mcu_fd_sc_mcu7t5v0__clkbuf_16 VDD VSS Z I VNW VPW a_224_552#
X0 VSS.t3 I.t1 a_224_552# VPW.t20 nfet_05v0 ad=0.1053p pd=0.925u as=0.1053p ps=0.925u w=0.405u l=0.6u
X1 VSS.t13 a_224_552# Z.t21 VPW.t7 nfet_05v0 ad=0.1261p pd=1.005u as=0.1261p ps=1.005u w=0.485u l=0.6u
X2 a_224_552# I.t7 VDD.t2 VNW.t22 pfet_05v0 ad=0.2542p pd=1.44u as=0.2542p ps=1.44u w=0.82u l=0.5u
X3 Z.t1 a_224_552# VDD.t16 VNW.t10 pfet_05v0 ad=0.3782p pd=1.84u as=0.3782p ps=1.84u w=1.22u l=0.5u
X4 Z.t16 a_224_552# VSS.t16 VPW.t2 nfet_05v0 ad=0.1261p pd=1.005u as=0.1261p ps=1.005u w=0.485u l=0.6u
X5 VDD.t11 a_224_552# Z.t0 VNW.t5 pfet_05v0 ad=0.3782p pd=1.84u as=0.3782p ps=1.84u w=1.22u l=0.5u
X6 VDD.t19 a_224_552# Z.t8 VNW.t13 pfet_05v0 ad=0.3782p pd=1.84u as=0.3782p ps=1.84u w=1.22u l=0.5u
X7 Z.t12 a_224_552# VDD.t14 VNW.t8 pfet_05v0 ad=0.3782p pd=1.84u as=0.3782p ps=1.84u w=1.22u l=0.5u
X8 a_224_552# I.t13 VDD.t1 VNW.t16 pfet_05v0 ad=0.2542p pd=1.44u as=0.3608p ps=2.52u w=0.82u l=0.5u
X9 VDD.t9 a_224_552# Z.t2 VNW.t3 pfet_05v0 ad=0.3782p pd=1.84u as=0.3782p ps=1.84u w=1.22u l=0.5u
X10 Z.t20 a_224_552# VSS.t5 VPW.t6 nfet_05v0 ad=0.1261p pd=1.005u as=0.1261p ps=1.005u w=0.485u l=0.6u
X11 VSS.t12 a_224_552# Z.t15 VPW.t1 nfet_05v0 ad=0.1261p pd=1.005u as=0.1261p ps=1.005u w=0.485u l=0.6u
X12 VSS.t9 a_224_552# Z.t23 VPW.t9 nfet_05v0 ad=0.1261p pd=1.005u as=0.1261p ps=1.005u w=0.485u l=0.6u
X13 VDD.t21 a_224_552# Z.t4 VNW.t15 pfet_05v0 ad=0.5368p pd=3.32u as=0.3782p ps=1.84u w=1.22u l=0.5u
X14 Z.t18 a_224_552# VSS.t11 VPW.t4 nfet_05v0 ad=0.1261p pd=1.005u as=0.1261p ps=1.005u w=0.485u l=0.6u
X15 VSS.t4 I.t5 a_224_552# VPW.t16 nfet_05v0 ad=0.1053p pd=0.925u as=0.1782p ps=1.69u w=0.405u l=0.6u
X16 a_224_552# I.t11 VDD.t5 VNW.t18 pfet_05v0 ad=0.2542p pd=1.44u as=0.2542p ps=1.44u w=0.82u l=0.5u
X17 a_224_552# I.t2 VSS.t21 VPW.t19 nfet_05v0 ad=0.1053p pd=0.925u as=0.1053p ps=0.925u w=0.405u l=0.6u
X18 VSS.t15 a_224_552# Z.t25 VPW.t11 nfet_05v0 ad=0.1261p pd=1.005u as=0.1261p ps=1.005u w=0.485u l=0.6u
X19 Z.t30 a_224_552# VDD.t6 VNW.t0 pfet_05v0 ad=0.3782p pd=1.84u as=0.428p ps=2.02u w=1.22u l=0.5u
X20 VDD.t22 I.t8 a_224_552# VNW.t21 pfet_05v0 ad=0.2542p pd=1.44u as=0.2542p ps=1.44u w=0.82u l=0.5u
X21 Z.t6 a_224_552# VDD.t20 VNW.t14 pfet_05v0 ad=0.3782p pd=1.84u as=0.3782p ps=1.84u w=1.22u l=0.5u
X22 Z.t7 a_224_552# VDD.t18 VNW.t12 pfet_05v0 ad=0.3782p pd=1.84u as=0.3782p ps=1.84u w=1.22u l=0.5u
X23 VSS.t0 I.t3 a_224_552# VPW.t18 nfet_05v0 ad=0.1053p pd=0.925u as=0.1053p ps=0.925u w=0.405u l=0.6u
X24 VDD.t13 a_224_552# Z.t9 VNW.t7 pfet_05v0 ad=0.3782p pd=1.84u as=0.3782p ps=1.84u w=1.22u l=0.5u
X25 Z.t24 a_224_552# VSS.t7 VPW.t10 nfet_05v0 ad=0.1261p pd=1.005u as=0.1261p ps=1.005u w=0.485u l=0.6u
X26 VSS.t20 a_224_552# Z.t19 VPW.t5 nfet_05v0 ad=0.1261p pd=1.005u as=0.1261p ps=1.005u w=0.485u l=0.6u
X27 VSS.t6 a_224_552# Z.t27 VPW.t13 nfet_05v0 ad=0.1261p pd=1.005u as=0.1261p ps=1.005u w=0.485u l=0.6u
X28 VDD.t23 I.t6 a_224_552# VNW.t23 pfet_05v0 ad=0.428p pd=2.02u as=0.2542p ps=1.44u w=0.82u l=0.5u
X29 Z.t11 a_224_552# VDD.t8 VNW.t2 pfet_05v0 ad=0.3782p pd=1.84u as=0.3782p ps=1.84u w=1.22u l=0.5u
X30 a_224_552# I.t0 VSS.t1 VPW.t21 nfet_05v0 ad=0.1782p pd=1.69u as=0.1053p ps=0.925u w=0.405u l=0.6u
X31 Z.t22 a_224_552# VSS.t10 VPW.t8 nfet_05v0 ad=0.1261p pd=1.005u as=0.1261p ps=1.005u w=0.485u l=0.6u
X32 VSS.t17 a_224_552# Z.t17 VPW.t3 nfet_05v0 ad=0.1261p pd=1.005u as=0.1261p ps=1.005u w=0.485u l=0.6u
X33 Z.t10 a_224_552# VDD.t12 VNW.t6 pfet_05v0 ad=0.3782p pd=1.84u as=0.3782p ps=1.84u w=1.22u l=0.5u
X34 VSS.t8 a_224_552# Z.t29 VPW.t15 nfet_05v0 ad=0.2134p pd=1.85u as=0.1261p ps=1.005u w=0.485u l=0.6u
X35 VDD.t3 I.t12 a_224_552# VNW.t17 pfet_05v0 ad=0.2542p pd=1.44u as=0.2542p ps=1.44u w=0.82u l=0.5u
X36 VDD.t7 a_224_552# Z.t31 VNW.t1 pfet_05v0 ad=0.3782p pd=1.84u as=0.3782p ps=1.84u w=1.22u l=0.5u
X37 VDD.t15 a_224_552# Z.t5 VNW.t9 pfet_05v0 ad=0.3782p pd=1.84u as=0.3782p ps=1.84u w=1.22u l=0.5u
X38 Z.t3 a_224_552# VDD.t10 VNW.t4 pfet_05v0 ad=0.3782p pd=1.84u as=0.3782p ps=1.84u w=1.22u l=0.5u
X39 a_224_552# I.t9 VDD.t0 VNW.t20 pfet_05v0 ad=0.2542p pd=1.44u as=0.2542p ps=1.44u w=0.82u l=0.5u
X40 a_224_552# I.t4 VSS.t2 VPW.t17 nfet_05v0 ad=0.1053p pd=0.925u as=0.1053p ps=0.925u w=0.405u l=0.6u
X41 Z.t14 a_224_552# VSS.t14 VPW.t0 nfet_05v0 ad=0.1261p pd=1.005u as=0.2134p ps=1.85u w=0.485u l=0.6u
X42 VDD.t4 I.t10 a_224_552# VNW.t19 pfet_05v0 ad=0.2542p pd=1.44u as=0.2542p ps=1.44u w=0.82u l=0.5u
X43 VDD.t17 a_224_552# Z.t13 VNW.t11 pfet_05v0 ad=0.3782p pd=1.84u as=0.3782p ps=1.84u w=1.22u l=0.5u
X44 Z.t28 a_224_552# VSS.t19 VPW.t14 nfet_05v0 ad=0.1261p pd=1.005u as=0.1261p ps=1.005u w=0.485u l=0.6u
X45 Z.t26 a_224_552# VSS.t18 VPW.t12 nfet_05v0 ad=0.1261p pd=1.005u as=0.1261p ps=1.005u w=0.485u l=0.6u
R0 VSS.n9 VSS.t8 10.1647
R1 VSS.n16 VSS.t14 9.82208
R2 VSS VSS.n19 6.65287
R3 VSS.n17 VSS.n1 6.46462
R4 VSS.n18 VSS.n0 6.46462
R5 VSS.n9 VSS.n8 6.45138
R6 VSS.n10 VSS.n7 6.45138
R7 VSS.n11 VSS.n6 6.45138
R8 VSS.n12 VSS.n5 6.45138
R9 VSS.n13 VSS.n4 6.45138
R10 VSS.n14 VSS.n3 6.45138
R11 VSS.n15 VSS.n2 6.45138
R12 VSS.n1 VSS.t1 4.04494
R13 VSS.n1 VSS.t3 4.04494
R14 VSS.n0 VSS.t21 4.04494
R15 VSS.n0 VSS.t0 4.04494
R16 VSS.n19 VSS.t2 4.04494
R17 VSS.n19 VSS.t4 4.04494
R18 VSS.n8 VSS.t19 3.37782
R19 VSS.n8 VSS.t6 3.37782
R20 VSS.n7 VSS.t18 3.37782
R21 VSS.n7 VSS.t15 3.37782
R22 VSS.n6 VSS.t7 3.37782
R23 VSS.n6 VSS.t9 3.37782
R24 VSS.n5 VSS.t10 3.37782
R25 VSS.n5 VSS.t13 3.37782
R26 VSS.n4 VSS.t5 3.37782
R27 VSS.n4 VSS.t20 3.37782
R28 VSS.n3 VSS.t11 3.37782
R29 VSS.n3 VSS.t17 3.37782
R30 VSS.n2 VSS.t16 3.37782
R31 VSS.n2 VSS.t12 3.37782
R32 VSS.n17 VSS.n16 0.3635
R33 VSS.n10 VSS.n9 0.3365
R34 VSS.n11 VSS.n10 0.3365
R35 VSS.n12 VSS.n11 0.3365
R36 VSS.n13 VSS.n12 0.3365
R37 VSS.n14 VSS.n13 0.3365
R38 VSS.n15 VSS.n14 0.3365
R39 VSS.n16 VSS.n15 0.3365
R40 VSS.n18 VSS.n17 0.3365
R41 VSS VSS.n18 0.14825
R42 Z.n26 Z.n25 7.0655
R43 Z.n19 Z.n18 7.0655
R44 Z.n28 Z.n22 6.4355
R45 Z.n27 Z.n23 6.4355
R46 Z.n26 Z.n24 6.4355
R47 Z.n19 Z.n17 6.4355
R48 Z.n20 Z.n16 6.4355
R49 Z.n21 Z.n15 6.4355
R50 Z.n22 Z.t23 3.37782
R51 Z.n22 Z.t22 3.37782
R52 Z.n23 Z.t25 3.37782
R53 Z.n23 Z.t24 3.37782
R54 Z.n24 Z.t27 3.37782
R55 Z.n24 Z.t26 3.37782
R56 Z.n25 Z.t29 3.37782
R57 Z.n25 Z.t28 3.37782
R58 Z.n18 Z.t15 3.37782
R59 Z.n18 Z.t14 3.37782
R60 Z.n17 Z.t17 3.37782
R61 Z.n17 Z.t16 3.37782
R62 Z.n16 Z.t19 3.37782
R63 Z.n16 Z.t18 3.37782
R64 Z.n15 Z.t21 3.37782
R65 Z.n15 Z.t20 3.37782
R66 Z.n9 Z.n7 2.94809
R67 Z.n2 Z.n0 2.93257
R68 Z.n6 Z.n5 2.6005
R69 Z.n4 Z.n3 2.6005
R70 Z.n2 Z.n1 2.6005
R71 Z.n9 Z.n8 2.6005
R72 Z.n11 Z.n10 2.6005
R73 Z.n13 Z.n12 2.6005
R74 Z.n12 Z.t5 2.06607
R75 Z.n10 Z.t13 2.06607
R76 Z.n8 Z.t8 2.06607
R77 Z.n7 Z.t4 2.06607
R78 Z.n0 Z.t30 2.06607
R79 Z.n1 Z.t2 2.06607
R80 Z.n3 Z.t0 2.06607
R81 Z.n5 Z.t9 2.06607
R82 Z.n12 Z.t12 1.4923
R83 Z.n10 Z.t1 1.4923
R84 Z.n8 Z.t7 1.4923
R85 Z.n7 Z.t6 1.4923
R86 Z.n0 Z.t31 1.4923
R87 Z.n1 Z.t11 1.4923
R88 Z.n3 Z.t3 1.4923
R89 Z.n5 Z.t10 1.4923
R90 Z.n21 Z.n20 0.6305
R91 Z.n20 Z.n19 0.6305
R92 Z.n27 Z.n26 0.6305
R93 Z.n28 Z.n27 0.6305
R94 Z.n6 Z.n4 0.348086
R95 Z.n4 Z.n2 0.348086
R96 Z.n11 Z.n9 0.348086
R97 Z.n13 Z.n11 0.348086
R98 Z.n29 Z.n28 0.195969
R99 Z.n29 Z.n21 0.181906
R100 Z.n14 Z.n6 0.116103
R101 Z.n14 Z.n13 0.0928276
R102 Z Z.n14 0.0755
R103 Z Z.n29 0.059
R104 VDD.n21 VDD.t1 7.8271
R105 VDD.n21 VDD.n20 5.35702
R106 VDD.n19 VDD.n0 5.35702
R107 VDD.n18 VDD.n1 5.35702
R108 VDD.n17 VDD.n2 5.28659
R109 VDD.n16 VDD.n3 5.28659
R110 VDD.n15 VDD.n4 5.28659
R111 VDD.n14 VDD.n5 5.28659
R112 VDD.n13 VDD.n6 5.28659
R113 VDD.n12 VDD.n7 5.28659
R114 VDD.n11 VDD.n8 5.28659
R115 VDD.n10 VDD.n9 5.28659
R116 VDD.n2 VDD.t23 4.61026
R117 VDD.n10 VDD.t21 4.60635
R118 VDD.n20 VDD.t5 3.07367
R119 VDD.n0 VDD.t0 3.07367
R120 VDD.n1 VDD.t2 3.07367
R121 VDD.n20 VDD.t3 2.22001
R122 VDD.n0 VDD.t4 2.22001
R123 VDD.n1 VDD.t22 2.22001
R124 VDD.n3 VDD.t8 2.06607
R125 VDD.n4 VDD.t10 2.06607
R126 VDD.n5 VDD.t12 2.06607
R127 VDD.n6 VDD.t14 2.06607
R128 VDD.n7 VDD.t16 2.06607
R129 VDD.n8 VDD.t18 2.06607
R130 VDD.n9 VDD.t20 2.06607
R131 VDD.n2 VDD.t6 1.52029
R132 VDD.n3 VDD.t7 1.4923
R133 VDD.n4 VDD.t9 1.4923
R134 VDD.n5 VDD.t11 1.4923
R135 VDD.n6 VDD.t13 1.4923
R136 VDD.n7 VDD.t15 1.4923
R137 VDD.n8 VDD.t17 1.4923
R138 VDD.n9 VDD.t19 1.4923
R139 VDD.n18 VDD.n17 0.3785
R140 VDD.n11 VDD.n10 0.3365
R141 VDD.n12 VDD.n11 0.3365
R142 VDD.n13 VDD.n12 0.3365
R143 VDD.n14 VDD.n13 0.3365
R144 VDD.n15 VDD.n14 0.3365
R145 VDD.n16 VDD.n15 0.3365
R146 VDD.n19 VDD.n18 0.3365
R147 VDD.n17 VDD.n16 0.3215
R148 VDD VDD.n21 0.20375
R149 VDD VDD.n19 0.13325
R150 I.n3 I.t13 31.7717
R151 I.n0 I.t6 29.7439
R152 I.n3 I.t12 18.7615
R153 I.n4 I.t11 18.7615
R154 I.n0 I.t7 18.7615
R155 I.n1 I.t8 18.7615
R156 I.n2 I.t9 18.7615
R157 I.n5 I.t10 18.7615
R158 I.n3 I.t5 11.133
R159 I.n4 I.t4 11.133
R160 I.n0 I.t0 11.133
R161 I.n1 I.t1 11.133
R162 I.n2 I.t2 11.133
R163 I.n5 I.t3 11.133
R164 I.n4 I.n3 10.5449
R165 I.n1 I.n0 10.5449
R166 I.n2 I.n1 10.5449
R167 I.n5 I.n2 10.5449
R168 I.n5 I.n4 10.5449
R169 I I.n5 0.552085
R170 VNW.t23 VNW.t0 501.932
R171 VNW.t14 VNW.t15 432.433
R172 VNW.t13 VNW.t14 432.433
R173 VNW.t12 VNW.t13 432.433
R174 VNW.t11 VNW.t12 432.433
R175 VNW.t10 VNW.t11 432.433
R176 VNW.t9 VNW.t10 432.433
R177 VNW.t8 VNW.t9 432.433
R178 VNW.t7 VNW.t8 432.433
R179 VNW.t6 VNW.t7 432.433
R180 VNW.t5 VNW.t6 432.433
R181 VNW.t4 VNW.t5 432.433
R182 VNW.t3 VNW.t4 432.433
R183 VNW.t2 VNW.t3 432.433
R184 VNW.t1 VNW.t2 432.433
R185 VNW.t0 VNW.t1 432.433
R186 VNW.t22 VNW.t23 432.433
R187 VNW.t21 VNW.t22 432.433
R188 VNW.t20 VNW.t21 432.433
R189 VNW.t19 VNW.t20 432.433
R190 VNW.t18 VNW.t19 432.433
R191 VNW.t17 VNW.t18 432.433
R192 VNW.t16 VNW.t17 432.433
R193 VNW VNW.t16 202.703
R194 VPW.t21 VPW.t0 3591.32
R195 VPW VPW.t16 2522.83
R196 VPW.t14 VPW.t15 1662.1
R197 VPW.t13 VPW.t14 1662.1
R198 VPW.t12 VPW.t13 1662.1
R199 VPW.t11 VPW.t12 1662.1
R200 VPW.t10 VPW.t11 1662.1
R201 VPW.t9 VPW.t10 1662.1
R202 VPW.t8 VPW.t9 1662.1
R203 VPW.t7 VPW.t8 1662.1
R204 VPW.t6 VPW.t7 1662.1
R205 VPW.t5 VPW.t6 1662.1
R206 VPW.t4 VPW.t5 1662.1
R207 VPW.t3 VPW.t4 1662.1
R208 VPW.t2 VPW.t3 1662.1
R209 VPW.t1 VPW.t2 1662.1
R210 VPW.t0 VPW.t1 1662.1
R211 VPW.t20 VPW.t21 1662.1
R212 VPW.t19 VPW.t20 1662.1
R213 VPW.t18 VPW.t19 1662.1
R214 VPW.t17 VPW.t18 1662.1
R215 VPW.t16 VPW.t17 1662.1
C0 VNW Z 0.17052f
C1 VNW VDD 0.64611f
C2 a_224_552# I 2.96173f
C3 VDD Z 2.07727f
C4 I VSS 0.19522f
C5 a_224_552# VSS 1.20513f
C6 VNW I 1.522f
C7 a_224_552# VNW 2.37127f
C8 VNW VSS 0.01122f
C9 I Z 0.00355f
C10 a_224_552# Z 6.10835f
C11 Z VSS 1.62469f
C12 I VDD 0.26381f
C13 a_224_552# VDD 1.34463f
C14 VDD VSS 0.02047f
C15 VSS VPW 2.36588f
C16 Z VPW 0.44298f
C17 VDD VPW 1.24148f
C18 I VPW 2.39334f
C19 VNW VPW 9.13941f
C20 a_224_552# VPW 2.96257f
C21 VNW.t15 VPW 0.35662f
C22 VNW.t14 VPW 0.18322f
C23 VNW.t13 VPW 0.18322f
C24 VNW.t12 VPW 0.18322f
C25 VNW.t11 VPW 0.18322f
C26 VNW.t10 VPW 0.18322f
C27 VNW.t9 VPW 0.18322f
C28 VNW.t8 VPW 0.18322f
C29 VNW.t7 VPW 0.18322f
C30 VNW.t6 VPW 0.18322f
C31 VNW.t5 VPW 0.18322f
C32 VNW.t4 VPW 0.18322f
C33 VNW.t3 VPW 0.18322f
C34 VNW.t2 VPW 0.18322f
C35 VNW.t1 VPW 0.18322f
C36 VNW.t0 VPW 0.19794f
C37 VNW.t23 VPW 0.19794f
C38 VNW.t22 VPW 0.18322f
C39 VNW.t21 VPW 0.18322f
C40 VNW.t20 VPW 0.18322f
C41 VNW.t19 VPW 0.18322f
C42 VNW.t18 VPW 0.18322f
C43 VNW.t17 VPW 0.18322f
C44 VNW.t16 VPW 0.13455f
C45 I.t6 VPW 0.21463f
C46 I.t7 VPW 0.14826f
C47 I.t0 VPW 0.08243f
C48 I.n0 VPW 0.40584f
C49 I.t8 VPW 0.14826f
C50 I.t1 VPW 0.08243f
C51 I.n1 VPW 0.28859f
C52 I.t9 VPW 0.14826f
C53 I.t2 VPW 0.08243f
C54 I.n2 VPW 0.28859f
C55 I.t13 VPW 0.22463f
C56 I.t12 VPW 0.14826f
C57 I.t5 VPW 0.08243f
C58 I.n3 VPW 0.4086f
C59 I.t11 VPW 0.14826f
C60 I.t4 VPW 0.08243f
C61 I.n4 VPW 0.28859f
C62 I.t10 VPW 0.14826f
C63 I.t3 VPW 0.08243f
C64 I.n5 VPW 0.34287f
C65 VDD.t0 VPW 0.02399f
C66 VDD.t4 VPW 0.01732f
C67 VDD.n0 VPW 0.04171f
C68 VDD.t2 VPW 0.02399f
C69 VDD.t22 VPW 0.01732f
C70 VDD.n1 VPW 0.04171f
C71 VDD.t6 VPW 0.02713f
C72 VDD.t23 VPW 0.03598f
C73 VDD.n2 VPW 0.0762f
C74 VDD.t8 VPW 0.03569f
C75 VDD.t7 VPW 0.02577f
C76 VDD.n3 VPW 0.06163f
C77 VDD.t10 VPW 0.03569f
C78 VDD.t9 VPW 0.02577f
C79 VDD.n4 VPW 0.06163f
C80 VDD.t12 VPW 0.03569f
C81 VDD.t11 VPW 0.02577f
C82 VDD.n5 VPW 0.06163f
C83 VDD.t14 VPW 0.03569f
C84 VDD.t13 VPW 0.02577f
C85 VDD.n6 VPW 0.06163f
C86 VDD.t16 VPW 0.03569f
C87 VDD.t15 VPW 0.02577f
C88 VDD.n7 VPW 0.06163f
C89 VDD.t18 VPW 0.03569f
C90 VDD.t17 VPW 0.02577f
C91 VDD.n8 VPW 0.06163f
C92 VDD.t20 VPW 0.03569f
C93 VDD.t19 VPW 0.02577f
C94 VDD.n9 VPW 0.06163f
C95 VDD.t21 VPW 0.08339f
C96 VDD.n10 VPW 0.44433f
C97 VDD.n11 VPW 0.23282f
C98 VDD.n12 VPW 0.23282f
C99 VDD.n13 VPW 0.23282f
C100 VDD.n14 VPW 0.23282f
C101 VDD.n15 VPW 0.23282f
C102 VDD.n16 VPW 0.22795f
C103 VDD.n17 VPW 0.24307f
C104 VDD.n18 VPW 0.25297f
C105 VDD.n19 VPW 0.17326f
C106 VDD.t5 VPW 0.02399f
C107 VDD.t3 VPW 0.01732f
C108 VDD.n20 VPW 0.04171f
C109 VDD.t1 VPW 0.05335f
C110 VDD.n21 VPW 0.35059f
C111 Z.t31 VPW 0.06775f
C112 Z.t30 VPW 0.0938f
C113 Z.n0 VPW 0.19046f
C114 Z.t2 VPW 0.0938f
C115 Z.t11 VPW 0.06775f
C116 Z.n1 VPW 0.16155f
C117 Z.n2 VPW 0.7306f
C118 Z.t0 VPW 0.0938f
C119 Z.t3 VPW 0.06775f
C120 Z.n3 VPW 0.16155f
C121 Z.n4 VPW 0.51663f
C122 Z.t9 VPW 0.0938f
C123 Z.t10 VPW 0.06775f
C124 Z.n5 VPW 0.16155f
C125 Z.n6 VPW 0.33144f
C126 Z.t4 VPW 0.0938f
C127 Z.t6 VPW 0.06775f
C128 Z.n7 VPW 0.19311f
C129 Z.t8 VPW 0.0938f
C130 Z.t7 VPW 0.06775f
C131 Z.n8 VPW 0.16155f
C132 Z.n9 VPW 0.75272f
C133 Z.t13 VPW 0.0938f
C134 Z.t1 VPW 0.06775f
C135 Z.n10 VPW 0.16155f
C136 Z.n11 VPW 0.51663f
C137 Z.t5 VPW 0.0938f
C138 Z.t12 VPW 0.06775f
C139 Z.n12 VPW 0.16155f
C140 Z.n13 VPW 0.31286f
C141 Z.n14 VPW 0.42163f
C142 Z.t21 VPW 0.02693f
C143 Z.t20 VPW 0.02693f
C144 Z.n15 VPW 0.05459f
C145 Z.t19 VPW 0.02693f
C146 Z.t18 VPW 0.02693f
C147 Z.n16 VPW 0.05459f
C148 Z.t17 VPW 0.02693f
C149 Z.t16 VPW 0.02693f
C150 Z.n17 VPW 0.05459f
C151 Z.t15 VPW 0.02693f
C152 Z.t14 VPW 0.02693f
C153 Z.n18 VPW 0.07418f
C154 Z.n19 VPW 0.5571f
C155 Z.n20 VPW 0.35703f
C156 Z.n21 VPW 0.24802f
C157 Z.t23 VPW 0.02693f
C158 Z.t22 VPW 0.02693f
C159 Z.n22 VPW 0.05459f
C160 Z.t25 VPW 0.02693f
C161 Z.t24 VPW 0.02693f
C162 Z.n23 VPW 0.05459f
C163 Z.t27 VPW 0.02693f
C164 Z.t26 VPW 0.02693f
C165 Z.n24 VPW 0.05459f
C166 Z.t29 VPW 0.02693f
C167 Z.t28 VPW 0.02693f
C168 Z.n25 VPW 0.07418f
C169 Z.n26 VPW 0.5571f
C170 Z.n27 VPW 0.35703f
C171 Z.n28 VPW 0.25144f
C172 Z.n29 VPW 0.26553f
C173 VSS.t21 VPW 0.00716f
C174 VSS.t0 VPW 0.00716f
C175 VSS.n0 VPW 0.01483f
C176 VSS.t1 VPW 0.00716f
C177 VSS.t3 VPW 0.00716f
C178 VSS.n1 VPW 0.01483f
C179 VSS.t14 VPW 0.02226f
C180 VSS.t16 VPW 0.00858f
C181 VSS.t12 VPW 0.00858f
C182 VSS.n2 VPW 0.01759f
C183 VSS.t11 VPW 0.00858f
C184 VSS.t17 VPW 0.00858f
C185 VSS.n3 VPW 0.01759f
C186 VSS.t5 VPW 0.00858f
C187 VSS.t20 VPW 0.00858f
C188 VSS.n4 VPW 0.01759f
C189 VSS.t10 VPW 0.00858f
C190 VSS.t13 VPW 0.00858f
C191 VSS.n5 VPW 0.01759f
C192 VSS.t7 VPW 0.00858f
C193 VSS.t9 VPW 0.00858f
C194 VSS.n6 VPW 0.01759f
C195 VSS.t18 VPW 0.00858f
C196 VSS.t15 VPW 0.00858f
C197 VSS.n7 VPW 0.01759f
C198 VSS.t19 VPW 0.00858f
C199 VSS.t6 VPW 0.00858f
C200 VSS.n8 VPW 0.01759f
C201 VSS.t8 VPW 0.02815f
C202 VSS.n9 VPW 0.38547f
C203 VSS.n10 VPW 0.21412f
C204 VSS.n11 VPW 0.21412f
C205 VSS.n12 VPW 0.21412f
C206 VSS.n13 VPW 0.21412f
C207 VSS.n14 VPW 0.21412f
C208 VSS.n15 VPW 0.21412f
C209 VSS.n16 VPW 0.22751f
C210 VSS.n17 VPW 0.22394f
C211 VSS.n18 VPW 0.16536f
C212 VSS.t2 VPW 0.00716f
C213 VSS.t4 VPW 0.00716f
C214 VSS.n19 VPW 0.02324f
.ends

.subckt gf180mcu_fd_sc_mcu7t5v0__nand2_1 VDD VSS ZN A1 A2 VNW VPW a_245_68#
X0 ZN.t0 A2.t1 VDD.t0 VNW.t1 pfet_05v0 ad=0.2938p pd=1.65u as=0.4972p ps=3.14u w=1.13u l=0.5u
X1 ZN.t2 A1.t0 a_245_68# VPW.t0 nfet_05v0 ad=0.3608p pd=2.52u as=0.1312p ps=1.14u w=0.82u l=0.6u
X2 VDD.t1 A1.t1 ZN.t1 VNW.t0 pfet_05v0 ad=0.4972p pd=3.14u as=0.2938p ps=1.65u w=1.13u l=0.5u
X3 a_245_68# A2.t0 VSS.t0 VPW.t1 nfet_05v0 ad=0.1312p pd=1.14u as=0.3608p ps=2.52u w=0.82u l=0.6u
R0 VSS VSS.t0 8.56875
R1 ZN ZN.t2 8.56922
R2 ZN ZN.n0 3.27068
R3 ZN.n0 ZN.t1 1.61112
R4 ZN.n0 ZN.t0 1.61112
R5 VDD VDD.t0 4.61876
R6 VDD VDD.t1 4.61426
R7 A1.n0 A1.t1 18.9805
R8 A1.n0 A1.t0 11.4372
R9 A1 A1.n0 8.11576
R10 A2.n0 A2.t1 17.7395
R11 A2.n0 A2.t0 12.6782
R12 A2 A2.n0 4.07694
R13 VNW.t1 VNW.t0 393.822
R14 VNW VNW.t1 204.633
R15 VPW.t1 VPW.t0 1365.3
R16 VPW VPW.t1 868.152
C0 a_245_68# ZN 0
C1 VSS VDD 0.01771f
C2 VSS VNW 0.00617f
C3 VDD A2 0.04881f
C4 VNW A2 0.1254f
C5 VSS a_245_68# 0.00268f
C6 a_245_68# A2 0
C7 VSS ZN 0.09851f
C8 ZN A2 0.04777f
C9 VSS A2 0.05455f
C10 VDD A1 0.03659f
C11 VNW A1 0.11976f
C12 A1 a_245_68# 0.00883f
C13 VNW VDD 0.11309f
C14 VDD a_245_68# 0
C15 A1 ZN 0.36366f
C16 VSS A1 0.13214f
C17 A1 A2 0.2264f
C18 VDD ZN 0.247f
C19 VNW ZN 0.04177f
C20 VSS VPW 0.50157f
C21 ZN VPW 0.52441f
C22 VDD VPW 0.55769f
C23 A1 VPW 0.44883f
C24 A2 VPW 0.31386f
C25 VNW VPW 1.25295f
C26 VNW.t0 VPW 0.20476f
C27 VNW.t1 VPW 0.08601f
C28 A2.t1 VPW 0.12909f
C29 A2.t0 VPW 0.11166f
C30 A2.n0 VPW 0.15157f
C31 A1.t1 VPW 0.21268f
C32 A1.t0 VPW 0.16543f
C33 A1.n0 VPW 0.2398f
C34 VDD.t1 VPW 0.05986f
C35 VDD.t0 VPW 0.05994f
C36 ZN.t1 VPW 0.05531f
C37 ZN.t0 VPW 0.05531f
C38 ZN.n0 VPW 0.13468f
C39 ZN.t2 VPW 0.11744f
C40 VSS.t0 VPW 0.04543f
.ends

.subckt gf180mcu_fd_sc_mcu7t5v0__fillcap_8 VDD VSS VNW VPW a_36_472# a_572_375# a_124_375#
+ a_484_472#
X0 VDD.t1 a_572_375# a_484_472# VNW.t1 pfet_05v0 ad=0.5368p pd=3.32u as=0.5368p ps=3.32u w=1.22u l=1u
X1 a_572_375# a_484_472# VSS.t1 VPW.t1 nfet_05v0 ad=0.3608p pd=2.52u as=0.3608p ps=2.52u w=0.82u l=1u
X2 a_124_375# a_36_472# VSS.t0 VPW.t0 nfet_05v0 ad=0.3608p pd=2.52u as=0.3608p ps=2.52u w=0.82u l=1u
X3 VDD.t0 a_124_375# a_36_472# VNW.t0 pfet_05v0 ad=0.5368p pd=3.32u as=0.5368p ps=3.32u w=1.22u l=1u
R0 VSS VSS.t0 8.79332
R1 VSS VSS.t1 8.56532
R2 VDD VDD.t1 4.64235
R3 VDD VDD.t0 4.41435
R4 VNW.t0 VNW.t1 864.865
R5 VNW VNW.t0 299.228
R6 VPW.t0 VPW.t1 3324.2
R7 VPW VPW.t0 1157.53
C0 a_572_375# VSS 0.08332f
C1 VDD a_124_375# 0.14169f
C2 a_484_472# VSS 0.1536f
C3 a_36_472# VSS 0.15613f
C4 VNW VSS 0.00882f
C5 a_484_472# a_572_375# 0.30831f
C6 VNW a_572_375# 0.19553f
C7 a_36_472# a_484_472# 0.01328f
C8 VDD VSS 0.01318f
C9 a_124_375# VSS 0.1378f
C10 VNW a_484_472# 0.04268f
C11 VDD a_572_375# 0.14423f
C12 a_36_472# VNW 0.0456f
C13 a_124_375# a_572_375# 0.01222f
C14 VDD a_484_472# 0.1835f
C15 VDD a_36_472# 0.09598f
C16 a_124_375# a_484_472# 0.08674f
C17 a_36_472# a_124_375# 0.30831f
C18 VDD VNW 0.14742f
C19 a_124_375# VNW 0.19448f
C20 VSS VPW 0.80949f
C21 VDD VPW 0.82078f
C22 VNW VPW 1.7978f
C23 a_484_472# VPW 0.21516f
C24 a_36_472# VPW 0.27314f
C25 a_572_375# VPW 0.11265f
C26 a_124_375# VPW 0.06454f
C27 VNW.t1 VPW 0.31726f
C28 VNW.t0 VPW 0.17913f
C29 VDD.t1 VPW 0.0829f
C30 VDD.t0 VPW 0.07432f
C31 VSS.t1 VPW 0.04595f
C32 VSS.t0 VPW 0.04937f
.ends

.subckt counter clk count[0] count[1] count[2] count[3] VDD VSS
Xgf180mcu_fd_sc_mcu7t5v0__fillcap_4_0 VDD VSS VDD VSS gf180mcu_fd_sc_mcu7t5v0__fillcap_4_0/a_36_472#
+ gf180mcu_fd_sc_mcu7t5v0__fillcap_4_0/a_124_375# gf180mcu_fd_sc_mcu7t5v0__fillcap_4
Xgf180mcu_fd_sc_mcu7t5v0__fillcap_4_1 VDD VSS VDD VSS gf180mcu_fd_sc_mcu7t5v0__fillcap_4_1/a_36_472#
+ gf180mcu_fd_sc_mcu7t5v0__fillcap_4_1/a_124_375# gf180mcu_fd_sc_mcu7t5v0__fillcap_4
Xgf180mcu_fd_sc_mcu7t5v0__fillcap_4_2 VDD VSS VDD VSS gf180mcu_fd_sc_mcu7t5v0__fillcap_4_2/a_36_472#
+ gf180mcu_fd_sc_mcu7t5v0__fillcap_4_2/a_124_375# gf180mcu_fd_sc_mcu7t5v0__fillcap_4
Xgf180mcu_fd_sc_mcu7t5v0__fillcap_4_3 VDD VSS VDD VSS gf180mcu_fd_sc_mcu7t5v0__fillcap_4_3/a_36_472#
+ gf180mcu_fd_sc_mcu7t5v0__fillcap_4_3/a_124_375# gf180mcu_fd_sc_mcu7t5v0__fillcap_4
Xgf180mcu_fd_sc_mcu7t5v0__xnor2_1_0 VDD VSS gf180mcu_fd_sc_mcu7t5v0__dffq_1_0/D gf180mcu_fd_sc_mcu7t5v0__dlyb_1_2/I
+ gf180mcu_fd_sc_mcu7t5v0__xnor2_1_0/A2 VDD VSS gf180mcu_fd_sc_mcu7t5v0__xnor2_1_0/a_272_93#
+ gf180mcu_fd_sc_mcu7t5v0__xnor2_1_0/a_716_68# gf180mcu_fd_sc_mcu7t5v0__xnor2_1_0/a_930_497#
+ gf180mcu_fd_sc_mcu7t5v0__xnor2_1_0/a_64_93# gf180mcu_fd_sc_mcu7t5v0__xnor2_1
Xgf180mcu_fd_sc_mcu7t5v0__dlyb_1_0 VDD gf180mcu_fd_sc_mcu7t5v0__dlyb_1_0/I VSS count[1]
+ VDD VSS gf180mcu_fd_sc_mcu7t5v0__dlyb_1_0/a_671_644# gf180mcu_fd_sc_mcu7t5v0__dlyb_1_0/a_895_68#
+ gf180mcu_fd_sc_mcu7t5v0__dlyb_1_0/a_523_68# gf180mcu_fd_sc_mcu7t5v0__dlyb_1_0/a_47_68#
+ gf180mcu_fd_sc_mcu7t5v0__dlyb_1_0/a_503_644# gf180mcu_fd_sc_mcu7t5v0__dlyb_1_0/a_1147_68#
+ gf180mcu_fd_sc_mcu7t5v0__dlyb_1_0/a_1127_622# gf180mcu_fd_sc_mcu7t5v0__dlyb_1
Xgf180mcu_fd_sc_mcu7t5v0__fillcap_4_4 VDD VSS VDD VSS gf180mcu_fd_sc_mcu7t5v0__fillcap_4_4/a_36_472#
+ gf180mcu_fd_sc_mcu7t5v0__fillcap_4_4/a_124_375# gf180mcu_fd_sc_mcu7t5v0__fillcap_4
Xgf180mcu_fd_sc_mcu7t5v0__fillcap_32_0 VDD VSS VDD VSS gf180mcu_fd_sc_mcu7t5v0__fillcap_32_0/a_1916_375#
+ gf180mcu_fd_sc_mcu7t5v0__fillcap_32_0/a_1380_472# gf180mcu_fd_sc_mcu7t5v0__fillcap_32_0/a_3260_375#
+ gf180mcu_fd_sc_mcu7t5v0__fillcap_32_0/a_36_472# gf180mcu_fd_sc_mcu7t5v0__fillcap_32_0/a_932_472#
+ gf180mcu_fd_sc_mcu7t5v0__fillcap_32_0/a_2812_375# gf180mcu_fd_sc_mcu7t5v0__fillcap_32_0/a_2276_472#
+ gf180mcu_fd_sc_mcu7t5v0__fillcap_32_0/a_1828_472# gf180mcu_fd_sc_mcu7t5v0__fillcap_32_0/a_3172_472#
+ gf180mcu_fd_sc_mcu7t5v0__fillcap_32_0/a_572_375# gf180mcu_fd_sc_mcu7t5v0__fillcap_32_0/a_2724_472#
+ gf180mcu_fd_sc_mcu7t5v0__fillcap_32_0/a_124_375# gf180mcu_fd_sc_mcu7t5v0__fillcap_32_0/a_1468_375#
+ gf180mcu_fd_sc_mcu7t5v0__fillcap_32_0/a_1020_375# gf180mcu_fd_sc_mcu7t5v0__fillcap_32_0/a_484_472#
+ gf180mcu_fd_sc_mcu7t5v0__fillcap_32_0/a_2364_375# gf180mcu_fd_sc_mcu7t5v0__fillcap_32
Xgf180mcu_fd_sc_mcu7t5v0__xnor2_1_1 VDD VSS gf180mcu_fd_sc_mcu7t5v0__dffq_1_2/D gf180mcu_fd_sc_mcu7t5v0__dlyb_1_3/I
+ gf180mcu_fd_sc_mcu7t5v0__xnor2_1_1/A2 VDD VSS gf180mcu_fd_sc_mcu7t5v0__xnor2_1_1/a_272_93#
+ gf180mcu_fd_sc_mcu7t5v0__xnor2_1_1/a_716_68# gf180mcu_fd_sc_mcu7t5v0__xnor2_1_1/a_930_497#
+ gf180mcu_fd_sc_mcu7t5v0__xnor2_1_1/a_64_93# gf180mcu_fd_sc_mcu7t5v0__xnor2_1
Xgf180mcu_fd_sc_mcu7t5v0__dlyb_1_1 VDD gf180mcu_fd_sc_mcu7t5v0__dlyb_1_1/I VSS count[0]
+ VDD VSS gf180mcu_fd_sc_mcu7t5v0__dlyb_1_1/a_671_644# gf180mcu_fd_sc_mcu7t5v0__dlyb_1_1/a_895_68#
+ gf180mcu_fd_sc_mcu7t5v0__dlyb_1_1/a_523_68# gf180mcu_fd_sc_mcu7t5v0__dlyb_1_1/a_47_68#
+ gf180mcu_fd_sc_mcu7t5v0__dlyb_1_1/a_503_644# gf180mcu_fd_sc_mcu7t5v0__dlyb_1_1/a_1147_68#
+ gf180mcu_fd_sc_mcu7t5v0__dlyb_1_1/a_1127_622# gf180mcu_fd_sc_mcu7t5v0__dlyb_1
Xgf180mcu_fd_sc_mcu7t5v0__fillcap_4_5 VDD VSS VDD VSS gf180mcu_fd_sc_mcu7t5v0__fillcap_4_5/a_36_472#
+ gf180mcu_fd_sc_mcu7t5v0__fillcap_4_5/a_124_375# gf180mcu_fd_sc_mcu7t5v0__fillcap_4
Xgf180mcu_fd_sc_mcu7t5v0__fillcap_32_1 VDD VSS VDD VSS gf180mcu_fd_sc_mcu7t5v0__fillcap_32_1/a_1916_375#
+ gf180mcu_fd_sc_mcu7t5v0__fillcap_32_1/a_1380_472# gf180mcu_fd_sc_mcu7t5v0__fillcap_32_1/a_3260_375#
+ gf180mcu_fd_sc_mcu7t5v0__fillcap_32_1/a_36_472# gf180mcu_fd_sc_mcu7t5v0__fillcap_32_1/a_932_472#
+ gf180mcu_fd_sc_mcu7t5v0__fillcap_32_1/a_2812_375# gf180mcu_fd_sc_mcu7t5v0__fillcap_32_1/a_2276_472#
+ gf180mcu_fd_sc_mcu7t5v0__fillcap_32_1/a_1828_472# gf180mcu_fd_sc_mcu7t5v0__fillcap_32_1/a_3172_472#
+ gf180mcu_fd_sc_mcu7t5v0__fillcap_32_1/a_572_375# gf180mcu_fd_sc_mcu7t5v0__fillcap_32_1/a_2724_472#
+ gf180mcu_fd_sc_mcu7t5v0__fillcap_32_1/a_124_375# gf180mcu_fd_sc_mcu7t5v0__fillcap_32_1/a_1468_375#
+ gf180mcu_fd_sc_mcu7t5v0__fillcap_32_1/a_1020_375# gf180mcu_fd_sc_mcu7t5v0__fillcap_32_1/a_484_472#
+ gf180mcu_fd_sc_mcu7t5v0__fillcap_32_1/a_2364_375# gf180mcu_fd_sc_mcu7t5v0__fillcap_32
Xgf180mcu_fd_sc_mcu7t5v0__dlyb_1_2 VDD gf180mcu_fd_sc_mcu7t5v0__dlyb_1_2/I VSS count[3]
+ VDD VSS gf180mcu_fd_sc_mcu7t5v0__dlyb_1_2/a_671_644# gf180mcu_fd_sc_mcu7t5v0__dlyb_1_2/a_895_68#
+ gf180mcu_fd_sc_mcu7t5v0__dlyb_1_2/a_523_68# gf180mcu_fd_sc_mcu7t5v0__dlyb_1_2/a_47_68#
+ gf180mcu_fd_sc_mcu7t5v0__dlyb_1_2/a_503_644# gf180mcu_fd_sc_mcu7t5v0__dlyb_1_2/a_1147_68#
+ gf180mcu_fd_sc_mcu7t5v0__dlyb_1_2/a_1127_622# gf180mcu_fd_sc_mcu7t5v0__dlyb_1
Xgf180mcu_fd_sc_mcu7t5v0__fillcap_32_2 VDD VSS VDD VSS gf180mcu_fd_sc_mcu7t5v0__fillcap_32_2/a_1916_375#
+ gf180mcu_fd_sc_mcu7t5v0__fillcap_32_2/a_1380_472# gf180mcu_fd_sc_mcu7t5v0__fillcap_32_2/a_3260_375#
+ gf180mcu_fd_sc_mcu7t5v0__fillcap_32_2/a_36_472# gf180mcu_fd_sc_mcu7t5v0__fillcap_32_2/a_932_472#
+ gf180mcu_fd_sc_mcu7t5v0__fillcap_32_2/a_2812_375# gf180mcu_fd_sc_mcu7t5v0__fillcap_32_2/a_2276_472#
+ gf180mcu_fd_sc_mcu7t5v0__fillcap_32_2/a_1828_472# gf180mcu_fd_sc_mcu7t5v0__fillcap_32_2/a_3172_472#
+ gf180mcu_fd_sc_mcu7t5v0__fillcap_32_2/a_572_375# gf180mcu_fd_sc_mcu7t5v0__fillcap_32_2/a_2724_472#
+ gf180mcu_fd_sc_mcu7t5v0__fillcap_32_2/a_124_375# gf180mcu_fd_sc_mcu7t5v0__fillcap_32_2/a_1468_375#
+ gf180mcu_fd_sc_mcu7t5v0__fillcap_32_2/a_1020_375# gf180mcu_fd_sc_mcu7t5v0__fillcap_32_2/a_484_472#
+ gf180mcu_fd_sc_mcu7t5v0__fillcap_32_2/a_2364_375# gf180mcu_fd_sc_mcu7t5v0__fillcap_32
Xgf180mcu_fd_sc_mcu7t5v0__fillcap_4_6 VDD VSS VDD VSS gf180mcu_fd_sc_mcu7t5v0__fillcap_4_6/a_36_472#
+ gf180mcu_fd_sc_mcu7t5v0__fillcap_4_6/a_124_375# gf180mcu_fd_sc_mcu7t5v0__fillcap_4
Xgf180mcu_fd_sc_mcu7t5v0__dlyb_1_3 VDD gf180mcu_fd_sc_mcu7t5v0__dlyb_1_3/I VSS count[2]
+ VDD VSS gf180mcu_fd_sc_mcu7t5v0__dlyb_1_3/a_671_644# gf180mcu_fd_sc_mcu7t5v0__dlyb_1_3/a_895_68#
+ gf180mcu_fd_sc_mcu7t5v0__dlyb_1_3/a_523_68# gf180mcu_fd_sc_mcu7t5v0__dlyb_1_3/a_47_68#
+ gf180mcu_fd_sc_mcu7t5v0__dlyb_1_3/a_503_644# gf180mcu_fd_sc_mcu7t5v0__dlyb_1_3/a_1147_68#
+ gf180mcu_fd_sc_mcu7t5v0__dlyb_1_3/a_1127_622# gf180mcu_fd_sc_mcu7t5v0__dlyb_1
Xgf180mcu_fd_sc_mcu7t5v0__fillcap_4_7 VDD VSS VDD VSS gf180mcu_fd_sc_mcu7t5v0__fillcap_4_7/a_36_472#
+ gf180mcu_fd_sc_mcu7t5v0__fillcap_4_7/a_124_375# gf180mcu_fd_sc_mcu7t5v0__fillcap_4
Xgf180mcu_fd_sc_mcu7t5v0__fillcap_32_3 VDD VSS VDD VSS gf180mcu_fd_sc_mcu7t5v0__fillcap_32_3/a_1916_375#
+ gf180mcu_fd_sc_mcu7t5v0__fillcap_32_3/a_1380_472# gf180mcu_fd_sc_mcu7t5v0__fillcap_32_3/a_3260_375#
+ gf180mcu_fd_sc_mcu7t5v0__fillcap_32_3/a_36_472# gf180mcu_fd_sc_mcu7t5v0__fillcap_32_3/a_932_472#
+ gf180mcu_fd_sc_mcu7t5v0__fillcap_32_3/a_2812_375# gf180mcu_fd_sc_mcu7t5v0__fillcap_32_3/a_2276_472#
+ gf180mcu_fd_sc_mcu7t5v0__fillcap_32_3/a_1828_472# gf180mcu_fd_sc_mcu7t5v0__fillcap_32_3/a_3172_472#
+ gf180mcu_fd_sc_mcu7t5v0__fillcap_32_3/a_572_375# gf180mcu_fd_sc_mcu7t5v0__fillcap_32_3/a_2724_472#
+ gf180mcu_fd_sc_mcu7t5v0__fillcap_32_3/a_124_375# gf180mcu_fd_sc_mcu7t5v0__fillcap_32_3/a_1468_375#
+ gf180mcu_fd_sc_mcu7t5v0__fillcap_32_3/a_1020_375# gf180mcu_fd_sc_mcu7t5v0__fillcap_32_3/a_484_472#
+ gf180mcu_fd_sc_mcu7t5v0__fillcap_32_3/a_2364_375# gf180mcu_fd_sc_mcu7t5v0__fillcap_32
Xgf180mcu_fd_sc_mcu7t5v0__fillcap_32_4 VDD VSS VDD VSS gf180mcu_fd_sc_mcu7t5v0__fillcap_32_4/a_1916_375#
+ gf180mcu_fd_sc_mcu7t5v0__fillcap_32_4/a_1380_472# gf180mcu_fd_sc_mcu7t5v0__fillcap_32_4/a_3260_375#
+ gf180mcu_fd_sc_mcu7t5v0__fillcap_32_4/a_36_472# gf180mcu_fd_sc_mcu7t5v0__fillcap_32_4/a_932_472#
+ gf180mcu_fd_sc_mcu7t5v0__fillcap_32_4/a_2812_375# gf180mcu_fd_sc_mcu7t5v0__fillcap_32_4/a_2276_472#
+ gf180mcu_fd_sc_mcu7t5v0__fillcap_32_4/a_1828_472# gf180mcu_fd_sc_mcu7t5v0__fillcap_32_4/a_3172_472#
+ gf180mcu_fd_sc_mcu7t5v0__fillcap_32_4/a_572_375# gf180mcu_fd_sc_mcu7t5v0__fillcap_32_4/a_2724_472#
+ gf180mcu_fd_sc_mcu7t5v0__fillcap_32_4/a_124_375# gf180mcu_fd_sc_mcu7t5v0__fillcap_32_4/a_1468_375#
+ gf180mcu_fd_sc_mcu7t5v0__fillcap_32_4/a_1020_375# gf180mcu_fd_sc_mcu7t5v0__fillcap_32_4/a_484_472#
+ gf180mcu_fd_sc_mcu7t5v0__fillcap_32_4/a_2364_375# gf180mcu_fd_sc_mcu7t5v0__fillcap_32
Xgf180mcu_fd_sc_mcu7t5v0__fillcap_4_8 VDD VSS VDD VSS gf180mcu_fd_sc_mcu7t5v0__fillcap_4_8/a_36_472#
+ gf180mcu_fd_sc_mcu7t5v0__fillcap_4_8/a_124_375# gf180mcu_fd_sc_mcu7t5v0__fillcap_4
Xgf180mcu_fd_sc_mcu7t5v0__fillcap_4_10 VDD VSS VDD VSS gf180mcu_fd_sc_mcu7t5v0__fillcap_4_10/a_36_472#
+ gf180mcu_fd_sc_mcu7t5v0__fillcap_4_10/a_124_375# gf180mcu_fd_sc_mcu7t5v0__fillcap_4
Xgf180mcu_fd_sc_mcu7t5v0__fillcap_4_9 VDD VSS VDD VSS gf180mcu_fd_sc_mcu7t5v0__fillcap_4_9/a_36_472#
+ gf180mcu_fd_sc_mcu7t5v0__fillcap_4_9/a_124_375# gf180mcu_fd_sc_mcu7t5v0__fillcap_4
Xgf180mcu_fd_sc_mcu7t5v0__fillcap_16_0 VDD VSS VDD VSS gf180mcu_fd_sc_mcu7t5v0__fillcap_16_0/a_1380_472#
+ gf180mcu_fd_sc_mcu7t5v0__fillcap_16_0/a_36_472# gf180mcu_fd_sc_mcu7t5v0__fillcap_16_0/a_932_472#
+ gf180mcu_fd_sc_mcu7t5v0__fillcap_16_0/a_572_375# gf180mcu_fd_sc_mcu7t5v0__fillcap_16_0/a_124_375#
+ gf180mcu_fd_sc_mcu7t5v0__fillcap_16_0/a_1468_375# gf180mcu_fd_sc_mcu7t5v0__fillcap_16_0/a_1020_375#
+ gf180mcu_fd_sc_mcu7t5v0__fillcap_16_0/a_484_472# gf180mcu_fd_sc_mcu7t5v0__fillcap_16
Xgf180mcu_fd_sc_mcu7t5v0__fillcap_32_5 VDD VSS VDD VSS gf180mcu_fd_sc_mcu7t5v0__fillcap_32_5/a_1916_375#
+ gf180mcu_fd_sc_mcu7t5v0__fillcap_32_5/a_1380_472# gf180mcu_fd_sc_mcu7t5v0__fillcap_32_5/a_3260_375#
+ gf180mcu_fd_sc_mcu7t5v0__fillcap_32_5/a_36_472# gf180mcu_fd_sc_mcu7t5v0__fillcap_32_5/a_932_472#
+ gf180mcu_fd_sc_mcu7t5v0__fillcap_32_5/a_2812_375# gf180mcu_fd_sc_mcu7t5v0__fillcap_32_5/a_2276_472#
+ gf180mcu_fd_sc_mcu7t5v0__fillcap_32_5/a_1828_472# gf180mcu_fd_sc_mcu7t5v0__fillcap_32_5/a_3172_472#
+ gf180mcu_fd_sc_mcu7t5v0__fillcap_32_5/a_572_375# gf180mcu_fd_sc_mcu7t5v0__fillcap_32_5/a_2724_472#
+ gf180mcu_fd_sc_mcu7t5v0__fillcap_32_5/a_124_375# gf180mcu_fd_sc_mcu7t5v0__fillcap_32_5/a_1468_375#
+ gf180mcu_fd_sc_mcu7t5v0__fillcap_32_5/a_1020_375# gf180mcu_fd_sc_mcu7t5v0__fillcap_32_5/a_484_472#
+ gf180mcu_fd_sc_mcu7t5v0__fillcap_32_5/a_2364_375# gf180mcu_fd_sc_mcu7t5v0__fillcap_32
Xgf180mcu_fd_sc_mcu7t5v0__fillcap_4_11 VDD VSS VDD VSS gf180mcu_fd_sc_mcu7t5v0__fillcap_4_11/a_36_472#
+ gf180mcu_fd_sc_mcu7t5v0__fillcap_4_11/a_124_375# gf180mcu_fd_sc_mcu7t5v0__fillcap_4
Xgf180mcu_fd_sc_mcu7t5v0__fillcap_32_6 VDD VSS VDD VSS gf180mcu_fd_sc_mcu7t5v0__fillcap_32_6/a_1916_375#
+ gf180mcu_fd_sc_mcu7t5v0__fillcap_32_6/a_1380_472# gf180mcu_fd_sc_mcu7t5v0__fillcap_32_6/a_3260_375#
+ gf180mcu_fd_sc_mcu7t5v0__fillcap_32_6/a_36_472# gf180mcu_fd_sc_mcu7t5v0__fillcap_32_6/a_932_472#
+ gf180mcu_fd_sc_mcu7t5v0__fillcap_32_6/a_2812_375# gf180mcu_fd_sc_mcu7t5v0__fillcap_32_6/a_2276_472#
+ gf180mcu_fd_sc_mcu7t5v0__fillcap_32_6/a_1828_472# gf180mcu_fd_sc_mcu7t5v0__fillcap_32_6/a_3172_472#
+ gf180mcu_fd_sc_mcu7t5v0__fillcap_32_6/a_572_375# gf180mcu_fd_sc_mcu7t5v0__fillcap_32_6/a_2724_472#
+ gf180mcu_fd_sc_mcu7t5v0__fillcap_32_6/a_124_375# gf180mcu_fd_sc_mcu7t5v0__fillcap_32_6/a_1468_375#
+ gf180mcu_fd_sc_mcu7t5v0__fillcap_32_6/a_1020_375# gf180mcu_fd_sc_mcu7t5v0__fillcap_32_6/a_484_472#
+ gf180mcu_fd_sc_mcu7t5v0__fillcap_32_6/a_2364_375# gf180mcu_fd_sc_mcu7t5v0__fillcap_32
Xgf180mcu_fd_sc_mcu7t5v0__fillcap_16_1 VDD VSS VDD VSS gf180mcu_fd_sc_mcu7t5v0__fillcap_16_1/a_1380_472#
+ gf180mcu_fd_sc_mcu7t5v0__fillcap_16_1/a_36_472# gf180mcu_fd_sc_mcu7t5v0__fillcap_16_1/a_932_472#
+ gf180mcu_fd_sc_mcu7t5v0__fillcap_16_1/a_572_375# gf180mcu_fd_sc_mcu7t5v0__fillcap_16_1/a_124_375#
+ gf180mcu_fd_sc_mcu7t5v0__fillcap_16_1/a_1468_375# gf180mcu_fd_sc_mcu7t5v0__fillcap_16_1/a_1020_375#
+ gf180mcu_fd_sc_mcu7t5v0__fillcap_16_1/a_484_472# gf180mcu_fd_sc_mcu7t5v0__fillcap_16
Xgf180mcu_fd_sc_mcu7t5v0__fillcap_4_12 VDD VSS VDD VSS gf180mcu_fd_sc_mcu7t5v0__fillcap_4_12/a_36_472#
+ gf180mcu_fd_sc_mcu7t5v0__fillcap_4_12/a_124_375# gf180mcu_fd_sc_mcu7t5v0__fillcap_4
Xgf180mcu_fd_sc_mcu7t5v0__fillcap_16_2 VDD VSS VDD VSS gf180mcu_fd_sc_mcu7t5v0__fillcap_16_2/a_1380_472#
+ gf180mcu_fd_sc_mcu7t5v0__fillcap_16_2/a_36_472# gf180mcu_fd_sc_mcu7t5v0__fillcap_16_2/a_932_472#
+ gf180mcu_fd_sc_mcu7t5v0__fillcap_16_2/a_572_375# gf180mcu_fd_sc_mcu7t5v0__fillcap_16_2/a_124_375#
+ gf180mcu_fd_sc_mcu7t5v0__fillcap_16_2/a_1468_375# gf180mcu_fd_sc_mcu7t5v0__fillcap_16_2/a_1020_375#
+ gf180mcu_fd_sc_mcu7t5v0__fillcap_16_2/a_484_472# gf180mcu_fd_sc_mcu7t5v0__fillcap_16
Xgf180mcu_fd_sc_mcu7t5v0__fillcap_4_13 VDD VSS VDD VSS gf180mcu_fd_sc_mcu7t5v0__fillcap_4_13/a_36_472#
+ gf180mcu_fd_sc_mcu7t5v0__fillcap_4_13/a_124_375# gf180mcu_fd_sc_mcu7t5v0__fillcap_4
Xgf180mcu_fd_sc_mcu7t5v0__nand3_1_0 gf180mcu_fd_sc_mcu7t5v0__dlyb_1_0/I VDD VSS gf180mcu_fd_sc_mcu7t5v0__xnor2_1_0/A2
+ gf180mcu_fd_sc_mcu7t5v0__dlyb_1_3/I gf180mcu_fd_sc_mcu7t5v0__dlyb_1_1/I VDD VSS
+ gf180mcu_fd_sc_mcu7t5v0__nand3_1_0/a_455_68# gf180mcu_fd_sc_mcu7t5v0__nand3_1_0/a_271_68#
+ gf180mcu_fd_sc_mcu7t5v0__nand3_1
Xgf180mcu_fd_sc_mcu7t5v0__xor2_1_0 VDD VSS gf180mcu_fd_sc_mcu7t5v0__xor2_1_0/Z gf180mcu_fd_sc_mcu7t5v0__dlyb_1_1/I
+ gf180mcu_fd_sc_mcu7t5v0__dlyb_1_0/I VDD VSS gf180mcu_fd_sc_mcu7t5v0__xor2_1_0/a_952_68#
+ gf180mcu_fd_sc_mcu7t5v0__xor2_1_0/a_728_472# gf180mcu_fd_sc_mcu7t5v0__xor2_1_0/a_244_604#
+ gf180mcu_fd_sc_mcu7t5v0__xor2_1_0/a_56_604# gf180mcu_fd_sc_mcu7t5v0__xor2_1
Xgf180mcu_fd_sc_mcu7t5v0__dffq_1_0 VDD gf180mcu_fd_sc_mcu7t5v0__dlyb_1_2/I gf180mcu_fd_sc_mcu7t5v0__dffq_1_2/CLK
+ VSS gf180mcu_fd_sc_mcu7t5v0__dffq_1_0/D VDD VSS gf180mcu_fd_sc_mcu7t5v0__dffq_1_0/a_2011_527#
+ gf180mcu_fd_sc_mcu7t5v0__dffq_1_0/a_448_472# gf180mcu_fd_sc_mcu7t5v0__dffq_1_0/a_880_527#
+ gf180mcu_fd_sc_mcu7t5v0__dffq_1_0/a_36_151# gf180mcu_fd_sc_mcu7t5v0__dffq_1_0/a_2304_115#
+ gf180mcu_fd_sc_mcu7t5v0__dffq_1_0/a_2256_159# gf180mcu_fd_sc_mcu7t5v0__dffq_1_0/a_1328_159#
+ gf180mcu_fd_sc_mcu7t5v0__dffq_1_0/a_2296_527# gf180mcu_fd_sc_mcu7t5v0__dffq_1_0/a_1348_527#
+ gf180mcu_fd_sc_mcu7t5v0__dffq_1_0/a_1004_159# gf180mcu_fd_sc_mcu7t5v0__dffq_1_0/a_1376_115#
+ gf180mcu_fd_sc_mcu7t5v0__dffq_1_0/a_836_159# gf180mcu_fd_sc_mcu7t5v0__dffq_1
Xgf180mcu_fd_sc_mcu7t5v0__clkinv_1_0 VDD VSS gf180mcu_fd_sc_mcu7t5v0__dlyb_1_1/I gf180mcu_fd_sc_mcu7t5v0__dffq_1_1/D
+ VDD VSS gf180mcu_fd_sc_mcu7t5v0__clkinv_1
Xgf180mcu_fd_sc_mcu7t5v0__dffq_1_1 VDD gf180mcu_fd_sc_mcu7t5v0__dlyb_1_1/I gf180mcu_fd_sc_mcu7t5v0__dffq_1_3/CLK
+ VSS gf180mcu_fd_sc_mcu7t5v0__dffq_1_1/D VDD VSS gf180mcu_fd_sc_mcu7t5v0__dffq_1_1/a_2011_527#
+ gf180mcu_fd_sc_mcu7t5v0__dffq_1_1/a_448_472# gf180mcu_fd_sc_mcu7t5v0__dffq_1_1/a_880_527#
+ gf180mcu_fd_sc_mcu7t5v0__dffq_1_1/a_36_151# gf180mcu_fd_sc_mcu7t5v0__dffq_1_1/a_2304_115#
+ gf180mcu_fd_sc_mcu7t5v0__dffq_1_1/a_2256_159# gf180mcu_fd_sc_mcu7t5v0__dffq_1_1/a_1328_159#
+ gf180mcu_fd_sc_mcu7t5v0__dffq_1_1/a_2296_527# gf180mcu_fd_sc_mcu7t5v0__dffq_1_1/a_1348_527#
+ gf180mcu_fd_sc_mcu7t5v0__dffq_1_1/a_1004_159# gf180mcu_fd_sc_mcu7t5v0__dffq_1_1/a_1376_115#
+ gf180mcu_fd_sc_mcu7t5v0__dffq_1_1/a_836_159# gf180mcu_fd_sc_mcu7t5v0__dffq_1
Xgf180mcu_fd_sc_mcu7t5v0__clkbuf_16_0 VDD VSS gf180mcu_fd_sc_mcu7t5v0__dffq_1_2/CLK
+ gf180mcu_fd_sc_mcu7t5v0__clkbuf_16_2/Z VDD VSS gf180mcu_fd_sc_mcu7t5v0__clkbuf_16_0/a_224_552#
+ gf180mcu_fd_sc_mcu7t5v0__clkbuf_16
Xgf180mcu_fd_sc_mcu7t5v0__dffq_1_2 VDD gf180mcu_fd_sc_mcu7t5v0__dlyb_1_3/I gf180mcu_fd_sc_mcu7t5v0__dffq_1_2/CLK
+ VSS gf180mcu_fd_sc_mcu7t5v0__dffq_1_2/D VDD VSS gf180mcu_fd_sc_mcu7t5v0__dffq_1_2/a_2011_527#
+ gf180mcu_fd_sc_mcu7t5v0__dffq_1_2/a_448_472# gf180mcu_fd_sc_mcu7t5v0__dffq_1_2/a_880_527#
+ gf180mcu_fd_sc_mcu7t5v0__dffq_1_2/a_36_151# gf180mcu_fd_sc_mcu7t5v0__dffq_1_2/a_2304_115#
+ gf180mcu_fd_sc_mcu7t5v0__dffq_1_2/a_2256_159# gf180mcu_fd_sc_mcu7t5v0__dffq_1_2/a_1328_159#
+ gf180mcu_fd_sc_mcu7t5v0__dffq_1_2/a_2296_527# gf180mcu_fd_sc_mcu7t5v0__dffq_1_2/a_1348_527#
+ gf180mcu_fd_sc_mcu7t5v0__dffq_1_2/a_1004_159# gf180mcu_fd_sc_mcu7t5v0__dffq_1_2/a_1376_115#
+ gf180mcu_fd_sc_mcu7t5v0__dffq_1_2/a_836_159# gf180mcu_fd_sc_mcu7t5v0__dffq_1
Xgf180mcu_fd_sc_mcu7t5v0__clkbuf_16_1 VDD VSS gf180mcu_fd_sc_mcu7t5v0__dffq_1_3/CLK
+ gf180mcu_fd_sc_mcu7t5v0__clkbuf_16_2/Z VDD VSS gf180mcu_fd_sc_mcu7t5v0__clkbuf_16_1/a_224_552#
+ gf180mcu_fd_sc_mcu7t5v0__clkbuf_16
Xgf180mcu_fd_sc_mcu7t5v0__dffq_1_3 VDD gf180mcu_fd_sc_mcu7t5v0__dlyb_1_0/I gf180mcu_fd_sc_mcu7t5v0__dffq_1_3/CLK
+ VSS gf180mcu_fd_sc_mcu7t5v0__xor2_1_0/Z VDD VSS gf180mcu_fd_sc_mcu7t5v0__dffq_1_3/a_2011_527#
+ gf180mcu_fd_sc_mcu7t5v0__dffq_1_3/a_448_472# gf180mcu_fd_sc_mcu7t5v0__dffq_1_3/a_880_527#
+ gf180mcu_fd_sc_mcu7t5v0__dffq_1_3/a_36_151# gf180mcu_fd_sc_mcu7t5v0__dffq_1_3/a_2304_115#
+ gf180mcu_fd_sc_mcu7t5v0__dffq_1_3/a_2256_159# gf180mcu_fd_sc_mcu7t5v0__dffq_1_3/a_1328_159#
+ gf180mcu_fd_sc_mcu7t5v0__dffq_1_3/a_2296_527# gf180mcu_fd_sc_mcu7t5v0__dffq_1_3/a_1348_527#
+ gf180mcu_fd_sc_mcu7t5v0__dffq_1_3/a_1004_159# gf180mcu_fd_sc_mcu7t5v0__dffq_1_3/a_1376_115#
+ gf180mcu_fd_sc_mcu7t5v0__dffq_1_3/a_836_159# gf180mcu_fd_sc_mcu7t5v0__dffq_1
Xgf180mcu_fd_sc_mcu7t5v0__clkbuf_16_2 VDD VSS gf180mcu_fd_sc_mcu7t5v0__clkbuf_16_2/Z
+ clk VDD VSS gf180mcu_fd_sc_mcu7t5v0__clkbuf_16_2/a_224_552# gf180mcu_fd_sc_mcu7t5v0__clkbuf_16
Xgf180mcu_fd_sc_mcu7t5v0__nand2_1_0 VDD VSS gf180mcu_fd_sc_mcu7t5v0__xnor2_1_1/A2
+ gf180mcu_fd_sc_mcu7t5v0__dlyb_1_1/I gf180mcu_fd_sc_mcu7t5v0__dlyb_1_0/I VDD VSS
+ gf180mcu_fd_sc_mcu7t5v0__nand2_1_0/a_245_68# gf180mcu_fd_sc_mcu7t5v0__nand2_1
Xgf180mcu_fd_sc_mcu7t5v0__fillcap_8_0 VDD VSS VDD VSS gf180mcu_fd_sc_mcu7t5v0__fillcap_8_0/a_36_472#
+ gf180mcu_fd_sc_mcu7t5v0__fillcap_8_0/a_572_375# gf180mcu_fd_sc_mcu7t5v0__fillcap_8_0/a_124_375#
+ gf180mcu_fd_sc_mcu7t5v0__fillcap_8_0/a_484_472# gf180mcu_fd_sc_mcu7t5v0__fillcap_8
Xgf180mcu_fd_sc_mcu7t5v0__fillcap_8_1 VDD VSS VDD VSS gf180mcu_fd_sc_mcu7t5v0__fillcap_8_1/a_36_472#
+ gf180mcu_fd_sc_mcu7t5v0__fillcap_8_1/a_572_375# gf180mcu_fd_sc_mcu7t5v0__fillcap_8_1/a_124_375#
+ gf180mcu_fd_sc_mcu7t5v0__fillcap_8_1/a_484_472# gf180mcu_fd_sc_mcu7t5v0__fillcap_8
R0 VDD VDD.n2 7001.93
R1 VDD.n28 VDD 4197.92
R2 VDD VDD 4118.06
R3 VDD VDD 4118.06
R4 VDD VDD 3888.89
R5 VDD VDD 3746.77
R6 VDD VDD 3554.55
R7 VDD VDD.n3 3542.47
R8 VDD VDD 2074.07
R9 VDD VDD 2074.07
R10 VDD VDD 1692.77
R11 VDD VDD 1692.77
R12 VDD VDD 1534.12
R13 VDD VDD 1404.49
R14 VDD VDD 1395.83
R15 VDD VDD 1037.04
R16 VDD VDD 1037.04
R17 VDD VDD 877.316
R18 VDD VDD 864.865
R19 VDD VDD.n33 568.288
R20 VDD VDD 518.519
R21 VDD VDD 518.519
R22 VDD VDD 518.519
R23 VDD VDD 518.519
R24 VDD VDD 518.519
R25 VDD VDD 518.519
R26 VDD.n2 VDD 349.421
R27 VDD.n3 VDD 349.421
R28 VDD VDD 311.312
R29 VDD VDD.n13 309.029
R30 VDD VDD 266.409
R31 VDD VDD 259.26
R32 VDD VDD 259.26
R33 VDD VDD 259.26
R34 VDD VDD 259.26
R35 VDD VDD 259.26
R36 VDD VDD 259.26
R37 VDD VDD 229.167
R38 VDD VDD 216.304
R39 VDD VDD 216.304
R40 VDD VDD 216.304
R41 VDD VDD 216.304
R42 VDD VDD 216.304
R43 VDD VDD.n5 209.492
R44 VDD.n7 VDD 209.492
R45 VDD.n13 VDD 209.492
R46 VDD VDD.n11 209.492
R47 VDD VDD.n17 209.492
R48 VDD.n19 VDD 209.492
R49 VDD VDD.n23 209.492
R50 VDD.n25 VDD 209.492
R51 VDD VDD.n29 209.492
R52 VDD.n33 VDD 209.492
R53 VDD VDD 186.212
R54 VDD VDD 186.212
R55 VDD VDD 186.212
R56 VDD VDD 186.212
R57 VDD VDD 186.212
R58 VDD.n5 VDD 179.399
R59 VDD VDD.n7 179.399
R60 VDD.n11 VDD 179.399
R61 VDD.n17 VDD 179.399
R62 VDD VDD.n19 179.399
R63 VDD.n23 VDD 179.399
R64 VDD VDD 159.722
R65 VDD VDD 159.722
R66 VDD VDD 159.722
R67 VDD VDD 159.722
R68 VDD VDD 159.722
R69 VDD VDD 159.722
R70 VDD VDD 159.722
R71 VDD VDD 129.631
R72 VDD VDD 129.631
R73 VDD VDD 129.631
R74 VDD VDD 129.631
R75 VDD VDD 129.631
R76 VDD VDD 129.631
R77 VDD VDD 129.631
R78 VDD VDD 129.631
R79 VDD VDD 129.631
R80 VDD VDD 129.631
R81 VDD VDD 129.631
R82 VDD VDD 99.5375
R83 VDD VDD.n25 49.769
R84 VDD.n29 VDD 49.769
R85 VDD VDD.n28 49.769
R86 VDD VDD 30.0931
R87 VDD VDD 30.0931
R88 VDD VDD 30.0931
R89 VDD.n10 VDD.n4 4.9415
R90 VDD.n10 VDD.n9 4.5005
R91 VDD.n16 VDD.n15 4.5005
R92 VDD.n21 VDD.n20 4.5005
R93 VDD.n27 VDD.n26 4.5005
R94 VDD.n35 VDD.n34 4.5005
R95 VDD.n31 VDD.n28 4.35924
R96 VDD.n30 VDD.n29 4.35923
R97 VDD VDD.n5 4.35913
R98 VDD VDD.n11 4.35913
R99 VDD VDD.n17 4.35913
R100 VDD VDD.n23 4.35913
R101 VDD.n3 VDD.n0 4.35814
R102 VDD.n2 VDD.n1 4.35814
R103 VDD.n7 VDD.n6 4.35814
R104 VDD.n13 VDD.n12 4.35814
R105 VDD.n19 VDD.n18 4.35814
R106 VDD.n25 VDD.n24 4.35814
R107 VDD.n33 VDD.n32 4.35814
R108 VDD.n26 VDD 2.07125
R109 VDD.n1 VDD 1.43375
R110 VDD VDD 1.42175
R111 VDD VDD 1.42175
R112 VDD VDD 1.42175
R113 VDD VDD 1.42175
R114 VDD VDD 1.25825
R115 VDD VDD 1.25375
R116 VDD VDD 1.2185
R117 VDD VDD.n8 1.05875
R118 VDD VDD 0.9395
R119 VDD.n22 VDD 0.9085
R120 VDD VDD 0.8825
R121 VDD VDD 0.881
R122 VDD VDD 0.8555
R123 VDD VDD 0.8555
R124 VDD VDD 0.8405
R125 VDD.n9 VDD 0.81125
R126 VDD VDD 0.7145
R127 VDD.n15 VDD.n14 0.6935
R128 VDD VDD 0.6725
R129 VDD VDD 0.66275
R130 VDD VDD 0.66275
R131 VDD VDD 0.54125
R132 VDD VDD 0.5045
R133 VDD VDD.n31 0.49475
R134 VDD.n4 VDD.n0 0.4925
R135 VDD VDD 0.4625
R136 VDD.n20 VDD 0.44975
R137 VDD.n16 VDD.n10 0.4415
R138 VDD.n21 VDD.n16 0.4415
R139 VDD.n35 VDD.n27 0.4415
R140 VDD VDD 0.4205
R141 VDD.n15 VDD 0.401
R142 VDD VDD 0.34175
R143 VDD VDD 0.33725
R144 VDD VDD 0.2945
R145 VDD VDD 0.287
R146 VDD VDD 0.287
R147 VDD.n27 VDD.n22 0.275563
R148 VDD.n4 VDD 0.2645
R149 VDD.n20 VDD 0.2645
R150 VDD.n34 VDD 0.2645
R151 VDD VDD 0.2525
R152 VDD VDD 0.2525
R153 VDD.n32 VDD 0.2525
R154 VDD VDD 0.2525
R155 VDD VDD 0.251
R156 VDD VDD 0.245
R157 VDD.n8 VDD 0.2435
R158 VDD.n34 VDD 0.2405
R159 VDD VDD.n35 0.237875
R160 VDD VDD 0.2105
R161 VDD VDD 0.20975
R162 VDD VDD 0.20975
R163 VDD VDD 0.20975
R164 VDD.n26 VDD 0.1985
R165 VDD.n12 VDD 0.176
R166 VDD VDD 0.1685
R167 VDD VDD 0.1685
R168 VDD VDD 0.16775
R169 VDD.n14 VDD 0.167
R170 VDD VDD.n30 0.167
R171 VDD.n22 VDD.n21 0.166437
R172 VDD VDD 0.161
R173 VDD VDD 0.1595
R174 VDD VDD 0.1595
R175 VDD VDD 0.1595
R176 VDD VDD 0.1595
R177 VDD VDD 0.134
R178 VDD VDD 0.13325
R179 VDD VDD 0.13325
R180 VDD VDD 0.13325
R181 VDD VDD 0.13325
R182 VDD VDD 0.12725
R183 VDD VDD 0.12725
R184 VDD.n6 VDD 0.12725
R185 VDD VDD 0.12725
R186 VDD VDD 0.12725
R187 VDD VDD 0.12725
R188 VDD VDD 0.12725
R189 VDD.n18 VDD 0.12725
R190 VDD VDD 0.12725
R191 VDD VDD 0.12725
R192 VDD.n24 VDD 0.12725
R193 VDD VDD 0.12725
R194 VDD VDD 0.12575
R195 VDD VDD 0.092
R196 VDD VDD 0.08525
R197 VDD VDD 0.0845
R198 VDD VDD 0.0845
R199 VDD VDD 0.0845
R200 VDD VDD 0.0845
R201 VDD VDD 0.0845
R202 VDD VDD 0.083
R203 VDD VDD 0.077
R204 VDD VDD 0.077
R205 VDD VDD 0.04925
R206 VDD VDD 0.04925
R207 VDD VDD 0.04925
R208 VDD VDD 0.04925
R209 VDD VDD 0.04175
R210 VDD.n9 VDD 0.0305
R211 VDD.n8 VDD 0.0200652
R212 VDD.n14 VDD 0.0200652
R213 VDD.n1 VDD 0.002
R214 VDD VDD.n0 0.002
R215 VDD VDD 0.002
R216 VDD.n6 VDD 0.002
R217 VDD VDD 0.002
R218 VDD.n12 VDD 0.002
R219 VDD VDD 0.002
R220 VDD.n18 VDD 0.002
R221 VDD VDD 0.002
R222 VDD.n24 VDD 0.002
R223 VDD.n30 VDD 0.002
R224 VDD.n31 VDD 0.002
R225 VDD.n32 VDD 0.002
R226 VSS.n49 VSS.n48 34771.3
R227 VSS VSS.n14 16748.6
R228 VSS VSS 16434.7
R229 VSS VSS 16434.7
R230 VSS VSS 15511.4
R231 VSS VSS 8272.73
R232 VSS VSS 8161.93
R233 VSS.n41 VSS 8010.19
R234 VSS.n15 VSS 7958.81
R235 VSS VSS 7644.89
R236 VSS VSS 7644.89
R237 VSS VSS 7644.89
R238 VSS VSS 6721.59
R239 VSS VSS 6610.8
R240 VSS VSS 6204.55
R241 VSS VSS 5576.7
R242 VSS VSS 5576.7
R243 VSS.n54 VSS.n53 5471.25
R244 VSS.n44 VSS.n43 4937.02
R245 VSS.n54 VSS 4062.5
R246 VSS.n50 VSS.n49 4050.87
R247 VSS.n51 VSS.n50 4050.87
R248 VSS.n52 VSS.n51 4050.87
R249 VSS.n53 VSS.n52 4050.87
R250 VSS.n48 VSS.n47 4003.14
R251 VSS.n47 VSS.n46 4003.14
R252 VSS.n46 VSS.n45 4003.14
R253 VSS.n45 VSS.n44 4003.14
R254 VSS VSS 2068.18
R255 VSS VSS 2068.18
R256 VSS VSS 2068.18
R257 VSS VSS 2068.18
R258 VSS VSS 2068.18
R259 VSS VSS 1978.26
R260 VSS.n24 VSS 1237.22
R261 VSS VSS.n1 1086.28
R262 VSS VSS 1034.09
R263 VSS VSS 1034.09
R264 VSS VSS 1034.09
R265 VSS VSS 1034.09
R266 VSS VSS 1034.09
R267 VSS VSS 1034.09
R268 VSS VSS 1034.09
R269 VSS VSS 989.13
R270 VSS VSS 989.13
R271 VSS.n48 VSS.n7 895.597
R272 VSS.n49 VSS.n6 895.597
R273 VSS.n47 VSS.n8 895.597
R274 VSS.n50 VSS.n5 895.597
R275 VSS.n46 VSS.n9 895.597
R276 VSS.n51 VSS.n4 895.597
R277 VSS.n45 VSS.n35 895.597
R278 VSS.n52 VSS.n3 895.597
R279 VSS.n44 VSS.n40 895.597
R280 VSS.n53 VSS.n2 895.597
R281 VSS VSS.n6 849.433
R282 VSS VSS.n5 849.433
R283 VSS VSS.n4 849.433
R284 VSS VSS.n3 849.433
R285 VSS VSS.n2 849.433
R286 VSS.n11 VSS 830.966
R287 VSS.n15 VSS 830.966
R288 VSS.n20 VSS 830.966
R289 VSS VSS.n19 830.966
R290 VSS.n25 VSS 830.966
R291 VSS VSS.n24 830.966
R292 VSS VSS.n34 830.966
R293 VSS.n10 VSS 830.966
R294 VSS VSS.n39 830.966
R295 VSS.n36 VSS 830.966
R296 VSS VSS.n7 738.636
R297 VSS VSS.n8 738.636
R298 VSS VSS.n9 738.636
R299 VSS.n35 VSS 738.636
R300 VSS.n40 VSS 738.636
R301 VSS.n20 VSS 720.17
R302 VSS.n19 VSS 720.17
R303 VSS.n25 VSS 720.17
R304 VSS.n34 VSS 720.17
R305 VSS.n39 VSS 720.17
R306 VSS.n36 VSS 720.17
R307 VSS VSS 627.841
R308 VSS VSS 627.841
R309 VSS VSS 627.841
R310 VSS VSS 627.841
R311 VSS VSS 627.841
R312 VSS VSS 627.841
R313 VSS VSS 627.841
R314 VSS VSS 517.045
R315 VSS VSS 517.045
R316 VSS VSS 517.045
R317 VSS VSS 517.045
R318 VSS VSS 517.045
R319 VSS VSS 517.045
R320 VSS VSS 517.045
R321 VSS VSS 517.045
R322 VSS VSS 517.045
R323 VSS VSS 517.045
R324 VSS VSS 517.045
R325 VSS VSS 406.25
R326 VSS.n41 VSS 397.418
R327 VSS VSS.n1 397.418
R328 VSS.n43 VSS 353.262
R329 VSS VSS 300.272
R330 VSS.n11 VSS 203.125
R331 VSS.n14 VSS 203.125
R332 VSS.n10 VSS 203.125
R333 VSS VSS 110.796
R334 VSS VSS 110.796
R335 VSS VSS 110.796
R336 VSS VSS 110.796
R337 VSS.n43 VSS 5.32526
R338 VSS VSS.n54 5.32526
R339 VSS.n12 VSS.n11 5.32359
R340 VSS VSS.n20 5.32359
R341 VSS VSS.n25 5.32359
R342 VSS.n34 VSS 5.32359
R343 VSS.n39 VSS 5.32359
R344 VSS.n55 VSS.n1 5.32226
R345 VSS.n42 VSS.n41 5.32226
R346 VSS.n14 VSS.n13 5.32226
R347 VSS.n17 VSS.n15 5.32226
R348 VSS.n21 VSS.n19 5.32226
R349 VSS.n26 VSS.n24 5.32226
R350 VSS.n33 VSS.n10 5.32226
R351 VSS.n38 VSS.n36 5.32226
R352 VSS.n23 VSS.n18 4.9415
R353 VSS.n57 VSS.n56 4.5005
R354 VSS.n37 VSS.n0 4.5005
R355 VSS.n32 VSS.n31 4.5005
R356 VSS.n29 VSS.n28 4.5005
R357 VSS.n23 VSS.n22 4.5005
R358 VSS VSS.n6 2.66571
R359 VSS VSS.n7 2.66571
R360 VSS VSS.n5 2.66571
R361 VSS VSS.n8 2.66571
R362 VSS VSS.n4 2.66571
R363 VSS VSS.n9 2.66571
R364 VSS VSS.n3 2.66571
R365 VSS.n35 VSS 2.66571
R366 VSS VSS.n2 2.66571
R367 VSS.n40 VSS 2.66571
R368 VSS.n42 VSS 1.42925
R369 VSS VSS 1.42625
R370 VSS VSS 1.42625
R371 VSS.n18 VSS 1.42475
R372 VSS.n56 VSS 1.42475
R373 VSS VSS 1.25825
R374 VSS VSS 1.25525
R375 VSS VSS 1.2185
R376 VSS VSS 1.09475
R377 VSS VSS 1.0565
R378 VSS.n30 VSS 0.991
R379 VSS VSS 0.9665
R380 VSS VSS 0.935
R381 VSS VSS 0.8885
R382 VSS VSS 0.8825
R383 VSS VSS 0.881
R384 VSS VSS 0.851
R385 VSS VSS 0.851
R386 VSS VSS 0.8405
R387 VSS VSS.n27 0.7895
R388 VSS.n17 VSS 0.7565
R389 VSS VSS 0.66275
R390 VSS VSS 0.66275
R391 VSS VSS 0.63275
R392 VSS VSS 0.5825
R393 VSS.n16 VSS 0.5495
R394 VSS.n27 VSS 0.5495
R395 VSS VSS 0.54875
R396 VSS VSS 0.5465
R397 VSS VSS 0.54575
R398 VSS VSS 0.5045
R399 VSS.n13 VSS 0.49475
R400 VSS VSS 0.4625
R401 VSS.n29 VSS.n23 0.4415
R402 VSS.n31 VSS.n0 0.4415
R403 VSS.n57 VSS.n0 0.4415
R404 VSS VSS 0.4205
R405 VSS VSS.n16 0.4175
R406 VSS VSS 0.33725
R407 VSS VSS 0.33425
R408 VSS VSS 0.29675
R409 VSS VSS 0.2885
R410 VSS VSS 0.2885
R411 VSS VSS 0.25475
R412 VSS VSS 0.2525
R413 VSS VSS 0.2525
R414 VSS VSS 0.2525
R415 VSS.n55 VSS 0.2525
R416 VSS VSS 0.251
R417 VSS VSS 0.25025
R418 VSS.n31 VSS.n30 0.240687
R419 VSS VSS 0.20825
R420 VSS VSS 0.20825
R421 VSS.n30 VSS.n29 0.201313
R422 VSS VSS 0.1685
R423 VSS VSS 0.1685
R424 VSS VSS.n12 0.167
R425 VSS VSS 0.16625
R426 VSS VSS 0.16625
R427 VSS VSS 0.1625
R428 VSS VSS 0.161
R429 VSS VSS 0.161
R430 VSS VSS 0.161
R431 VSS VSS 0.161
R432 VSS VSS 0.13025
R433 VSS VSS 0.13025
R434 VSS VSS 0.13025
R435 VSS VSS 0.13025
R436 VSS VSS 0.12875
R437 VSS VSS 0.12875
R438 VSS VSS 0.12875
R439 VSS VSS 0.12875
R440 VSS VSS 0.12875
R441 VSS VSS 0.12875
R442 VSS VSS 0.12875
R443 VSS VSS 0.12875
R444 VSS VSS 0.12425
R445 VSS.n28 VSS 0.0935
R446 VSS VSS 0.0905
R447 VSS VSS 0.0845
R448 VSS VSS 0.0845
R449 VSS VSS 0.0845
R450 VSS VSS 0.0845
R451 VSS VSS 0.083
R452 VSS.n22 VSS.n21 0.0815
R453 VSS.n28 VSS.n26 0.0815
R454 VSS.n33 VSS.n32 0.0815
R455 VSS.n38 VSS.n37 0.0815
R456 VSS VSS 0.0785
R457 VSS VSS 0.0785
R458 VSS.n22 VSS 0.04775
R459 VSS.n32 VSS 0.04775
R460 VSS.n37 VSS 0.04775
R461 VSS VSS 0.04625
R462 VSS VSS 0.04625
R463 VSS VSS 0.04625
R464 VSS VSS 0.04625
R465 VSS VSS 0.0425
R466 VSS VSS 0.0425
R467 VSS VSS 0.04025
R468 VSS VSS.n57 0.017375
R469 VSS.n16 VSS 0.0137353
R470 VSS.n27 VSS 0.0137353
R471 VSS.n12 VSS 0.002
R472 VSS.n13 VSS 0.002
R473 VSS.n18 VSS 0.002
R474 VSS VSS.n17 0.002
R475 VSS VSS 0.002
R476 VSS.n21 VSS 0.002
R477 VSS VSS 0.002
R478 VSS.n26 VSS 0.002
R479 VSS VSS 0.002
R480 VSS VSS.n33 0.002
R481 VSS VSS 0.002
R482 VSS VSS.n38 0.002
R483 VSS VSS.n42 0.002
R484 VSS.n56 VSS 0.002
R485 VSS VSS.n55 0.002
R486 count[0] count[0] 14.1755
R487 count[1] count[1] 13.4555
R488 clk.n3 clk.n0 31.7717
R489 clk.n10 clk.n7 29.7439
R490 clk.n10 clk.n9 18.7615
R491 clk.n13 clk.n12 18.7615
R492 clk.n16 clk.n15 18.7615
R493 clk.n3 clk.n2 18.7615
R494 clk.n6 clk.n5 18.7615
R495 clk.n19 clk.n18 18.7615
R496 clk clk 13.6596
R497 clk.n10 clk.n8 11.0722
R498 clk.n13 clk.n11 11.0722
R499 clk.n16 clk.n14 11.0722
R500 clk.n3 clk.n1 11.0722
R501 clk.n6 clk.n4 11.0722
R502 clk.n19 clk.n17 11.0722
R503 clk.n13 clk.n10 10.5449
R504 clk.n16 clk.n13 10.5449
R505 clk.n6 clk.n3 10.5449
R506 clk.n19 clk.n6 10.5449
R507 clk.n19 clk.n16 10.5449
R508 clk clk.n19 0.552085
R509 count[2] count[2] 12.1955
R510 count[3] count[3] 23.1755
C0 gf180mcu_fd_sc_mcu7t5v0__fillcap_4_9/a_124_375# gf180mcu_fd_sc_mcu7t5v0__fillcap_32_5/a_3260_375# 0.05841f
C1 gf180mcu_fd_sc_mcu7t5v0__fillcap_4_6/a_124_375# gf180mcu_fd_sc_mcu7t5v0__dlyb_1_3/I 0.01033f
C2 gf180mcu_fd_sc_mcu7t5v0__fillcap_32_2/a_2364_375# gf180mcu_fd_sc_mcu7t5v0__clkbuf_16_2/Z 0.03241f
C3 VDD gf180mcu_fd_sc_mcu7t5v0__dlyb_1_3/a_671_644# 0.02112f
C4 gf180mcu_fd_sc_mcu7t5v0__dffq_1_2/CLK gf180mcu_fd_sc_mcu7t5v0__dffq_1_2/a_836_159# 0
C5 VDD gf180mcu_fd_sc_mcu7t5v0__dffq_1_1/a_836_159# 0
C6 gf180mcu_fd_sc_mcu7t5v0__dlyb_1_3/a_671_644# gf180mcu_fd_sc_mcu7t5v0__dffq_1_0/a_2011_527# 0.02867f
C7 gf180mcu_fd_sc_mcu7t5v0__fillcap_8_1/a_124_375# gf180mcu_fd_sc_mcu7t5v0__dlyb_1_0/I 0
C8 gf180mcu_fd_sc_mcu7t5v0__xnor2_1_1/A2 gf180mcu_fd_sc_mcu7t5v0__dffq_1_3/a_1376_115# 0
C9 VDD gf180mcu_fd_sc_mcu7t5v0__fillcap_8_1/a_124_375# 0.00923f
C10 gf180mcu_fd_sc_mcu7t5v0__fillcap_32_5/a_2812_375# gf180mcu_fd_sc_mcu7t5v0__fillcap_16_0/a_1468_375# 0.05841f
C11 VDD gf180mcu_fd_sc_mcu7t5v0__dffq_1_2/a_2011_527# 0.05018f
C12 gf180mcu_fd_sc_mcu7t5v0__fillcap_32_0/a_1020_375# gf180mcu_fd_sc_mcu7t5v0__fillcap_32_1/a_932_472# 0.00168f
C13 VDD gf180mcu_fd_sc_mcu7t5v0__fillcap_32_0/a_3260_375# 0.04618f
C14 clk gf180mcu_fd_sc_mcu7t5v0__fillcap_32_5/a_2812_375# 0.00843f
C15 gf180mcu_fd_sc_mcu7t5v0__clkbuf_16_0/a_224_552# gf180mcu_fd_sc_mcu7t5v0__fillcap_32_6/a_1380_472# 0.01591f
C16 gf180mcu_fd_sc_mcu7t5v0__dlyb_1_1/I gf180mcu_fd_sc_mcu7t5v0__dffq_1_1/a_2304_115# 0.03862f
C17 gf180mcu_fd_sc_mcu7t5v0__fillcap_32_3/a_484_472# gf180mcu_fd_sc_mcu7t5v0__clkbuf_16_2/a_224_552# 0.001f
C18 gf180mcu_fd_sc_mcu7t5v0__dffq_1_0/a_1004_159# gf180mcu_fd_sc_mcu7t5v0__dffq_1_2/a_2304_115# 0.00165f
C19 gf180mcu_fd_sc_mcu7t5v0__fillcap_4_1/a_36_472# gf180mcu_fd_sc_mcu7t5v0__fillcap_4_1/a_124_375# 0
C20 gf180mcu_fd_sc_mcu7t5v0__dffq_1_3/CLK gf180mcu_fd_sc_mcu7t5v0__fillcap_32_0/a_932_472# 0
C21 gf180mcu_fd_sc_mcu7t5v0__dffq_1_2/a_448_472# gf180mcu_fd_sc_mcu7t5v0__fillcap_16_0/a_36_472# 0
C22 gf180mcu_fd_sc_mcu7t5v0__dffq_1_0/a_448_472# gf180mcu_fd_sc_mcu7t5v0__dffq_1_2/a_2304_115# 0.00163f
C23 gf180mcu_fd_sc_mcu7t5v0__fillcap_16_2/a_124_375# gf180mcu_fd_sc_mcu7t5v0__dlyb_1_0/a_47_68# 0.00653f
C24 gf180mcu_fd_sc_mcu7t5v0__fillcap_4_4/a_124_375# count[0] 0.00397f
C25 gf180mcu_fd_sc_mcu7t5v0__dlyb_1_3/a_523_68# gf180mcu_fd_sc_mcu7t5v0__dlyb_1_1/I 0
C26 gf180mcu_fd_sc_mcu7t5v0__dffq_1_2/D gf180mcu_fd_sc_mcu7t5v0__dffq_1_2/a_2011_527# 0.00364f
C27 gf180mcu_fd_sc_mcu7t5v0__dlyb_1_3/a_1127_622# gf180mcu_fd_sc_mcu7t5v0__dlyb_1_1/I 0
C28 gf180mcu_fd_sc_mcu7t5v0__fillcap_32_3/a_124_375# gf180mcu_fd_sc_mcu7t5v0__fillcap_32_0/a_484_472# 0.00154f
C29 gf180mcu_fd_sc_mcu7t5v0__dlyb_1_0/a_523_68# gf180mcu_fd_sc_mcu7t5v0__dlyb_1_1/I 0
C30 VDD gf180mcu_fd_sc_mcu7t5v0__fillcap_32_5/a_1828_472# -0
C31 gf180mcu_fd_sc_mcu7t5v0__fillcap_32_0/a_36_472# gf180mcu_fd_sc_mcu7t5v0__clkbuf_16_2/Z 0
C32 gf180mcu_fd_sc_mcu7t5v0__dffq_1_2/a_2304_115# gf180mcu_fd_sc_mcu7t5v0__clkbuf_16_2/Z 0
C33 gf180mcu_fd_sc_mcu7t5v0__xor2_1_0/Z gf180mcu_fd_sc_mcu7t5v0__dffq_1_3/a_2011_527# 0.03147f
C34 gf180mcu_fd_sc_mcu7t5v0__dffq_1_1/a_2304_115# gf180mcu_fd_sc_mcu7t5v0__xor2_1_0/a_728_472# 0
C35 gf180mcu_fd_sc_mcu7t5v0__fillcap_32_1/a_3260_375# gf180mcu_fd_sc_mcu7t5v0__fillcap_4_0/a_124_375# 0.012f
C36 gf180mcu_fd_sc_mcu7t5v0__fillcap_32_2/a_1828_472# gf180mcu_fd_sc_mcu7t5v0__clkbuf_16_1/a_224_552# 0
C37 gf180mcu_fd_sc_mcu7t5v0__dffq_1_2/CLK gf180mcu_fd_sc_mcu7t5v0__dffq_1_0/a_1004_159# 0
C38 gf180mcu_fd_sc_mcu7t5v0__dlyb_1_0/I gf180mcu_fd_sc_mcu7t5v0__fillcap_4_4/a_36_472# 0.00515f
C39 gf180mcu_fd_sc_mcu7t5v0__dffq_1_2/D gf180mcu_fd_sc_mcu7t5v0__fillcap_32_5/a_1828_472# 0
C40 VDD gf180mcu_fd_sc_mcu7t5v0__fillcap_4_4/a_36_472# 0.10657f
C41 gf180mcu_fd_sc_mcu7t5v0__fillcap_32_0/a_484_472# gf180mcu_fd_sc_mcu7t5v0__clkbuf_16_2/Z 0
C42 gf180mcu_fd_sc_mcu7t5v0__dffq_1_2/CLK gf180mcu_fd_sc_mcu7t5v0__dffq_1_0/a_448_472# 0.004f
C43 gf180mcu_fd_sc_mcu7t5v0__dffq_1_2/a_36_151# gf180mcu_fd_sc_mcu7t5v0__clkbuf_16_2/a_224_552# 0.01123f
C44 gf180mcu_fd_sc_mcu7t5v0__fillcap_32_5/a_572_375# gf180mcu_fd_sc_mcu7t5v0__clkbuf_16_2/a_224_552# 0.00118f
C45 gf180mcu_fd_sc_mcu7t5v0__clkbuf_16_1/a_224_552# gf180mcu_fd_sc_mcu7t5v0__fillcap_32_2/a_1020_375# 0.03233f
C46 gf180mcu_fd_sc_mcu7t5v0__fillcap_4_7/a_124_375# gf180mcu_fd_sc_mcu7t5v0__dffq_1_0/a_1376_115# 0
C47 gf180mcu_fd_sc_mcu7t5v0__clkbuf_16_1/a_224_552# gf180mcu_fd_sc_mcu7t5v0__dffq_1_1/a_448_472# 0.00748f
C48 gf180mcu_fd_sc_mcu7t5v0__clkbuf_16_1/a_224_552# gf180mcu_fd_sc_mcu7t5v0__dffq_1_1/a_1004_159# 0.00136f
C49 gf180mcu_fd_sc_mcu7t5v0__fillcap_4_8/a_36_472# gf180mcu_fd_sc_mcu7t5v0__clkbuf_16_2/Z 0
C50 gf180mcu_fd_sc_mcu7t5v0__dffq_1_2/CLK gf180mcu_fd_sc_mcu7t5v0__clkbuf_16_2/Z 0.08384f
C51 gf180mcu_fd_sc_mcu7t5v0__xnor2_1_1/A2 gf180mcu_fd_sc_mcu7t5v0__dffq_1_2/a_2011_527# 0.00131f
C52 gf180mcu_fd_sc_mcu7t5v0__fillcap_32_5/a_2364_375# gf180mcu_fd_sc_mcu7t5v0__fillcap_16_0/a_1020_375# 0.05841f
C53 gf180mcu_fd_sc_mcu7t5v0__xor2_1_0/Z gf180mcu_fd_sc_mcu7t5v0__dffq_1_1/a_2304_115# 0.01043f
C54 gf180mcu_fd_sc_mcu7t5v0__xnor2_1_1/a_272_93# gf180mcu_fd_sc_mcu7t5v0__dlyb_1_3/I 0
C55 gf180mcu_fd_sc_mcu7t5v0__fillcap_4_6/a_124_375# gf180mcu_fd_sc_mcu7t5v0__dlyb_1_2/I 0
C56 gf180mcu_fd_sc_mcu7t5v0__dlyb_1_0/I gf180mcu_fd_sc_mcu7t5v0__dffq_1_3/a_2011_527# 0.06246f
C57 gf180mcu_fd_sc_mcu7t5v0__fillcap_16_1/a_1020_375# gf180mcu_fd_sc_mcu7t5v0__dlyb_1_2/I 0
C58 gf180mcu_fd_sc_mcu7t5v0__xnor2_1_0/a_716_68# gf180mcu_fd_sc_mcu7t5v0__dffq_1_2/CLK 0
C59 gf180mcu_fd_sc_mcu7t5v0__fillcap_32_1/a_1020_375# gf180mcu_fd_sc_mcu7t5v0__fillcap_32_3/a_932_472# 0.0027f
C60 VDD gf180mcu_fd_sc_mcu7t5v0__fillcap_32_5/a_3172_472# -0
C61 gf180mcu_fd_sc_mcu7t5v0__dlyb_1_1/I gf180mcu_fd_sc_mcu7t5v0__xor2_1_0/a_244_604# 0.00271f
C62 VDD gf180mcu_fd_sc_mcu7t5v0__dffq_1_3/a_2011_527# 0.02258f
C63 gf180mcu_fd_sc_mcu7t5v0__clkbuf_16_1/a_224_552# gf180mcu_fd_sc_mcu7t5v0__fillcap_8_0/a_572_375# 0.03233f
C64 VDD gf180mcu_fd_sc_mcu7t5v0__fillcap_32_4/a_1916_375# 0.00198f
C65 gf180mcu_fd_sc_mcu7t5v0__fillcap_16_2/a_36_472# gf180mcu_fd_sc_mcu7t5v0__dffq_1_3/a_36_151# 0
C66 VDD gf180mcu_fd_sc_mcu7t5v0__fillcap_16_1/a_932_472# 0.02761f
C67 gf180mcu_fd_sc_mcu7t5v0__fillcap_16_0/a_1468_375# gf180mcu_fd_sc_mcu7t5v0__fillcap_4_9/a_124_375# 0.012f
C68 gf180mcu_fd_sc_mcu7t5v0__xnor2_1_1/a_716_68# gf180mcu_fd_sc_mcu7t5v0__dffq_1_2/a_448_472# 0
C69 clk gf180mcu_fd_sc_mcu7t5v0__fillcap_4_9/a_124_375# 0.00242f
C70 gf180mcu_fd_sc_mcu7t5v0__dlyb_1_1/I gf180mcu_fd_sc_mcu7t5v0__fillcap_4_6/a_124_375# 0
C71 gf180mcu_fd_sc_mcu7t5v0__dffq_1_2/CLK gf180mcu_fd_sc_mcu7t5v0__fillcap_32_5/a_932_472# 0
C72 gf180mcu_fd_sc_mcu7t5v0__clkbuf_16_0/a_224_552# gf180mcu_fd_sc_mcu7t5v0__fillcap_32_4/a_1468_375# 0.02641f
C73 gf180mcu_fd_sc_mcu7t5v0__clkbuf_16_0/a_224_552# gf180mcu_fd_sc_mcu7t5v0__fillcap_32_4/a_3260_375# 0.00129f
C74 gf180mcu_fd_sc_mcu7t5v0__fillcap_32_4/a_2364_375# gf180mcu_fd_sc_mcu7t5v0__clkbuf_16_2/Z 0.04256f
C75 gf180mcu_fd_sc_mcu7t5v0__dffq_1_3/CLK gf180mcu_fd_sc_mcu7t5v0__fillcap_4_13/a_36_472# 0
C76 VDD gf180mcu_fd_sc_mcu7t5v0__fillcap_32_2/a_2812_375# 0.00122f
C77 gf180mcu_fd_sc_mcu7t5v0__fillcap_4_2/a_36_472# gf180mcu_fd_sc_mcu7t5v0__fillcap_32_3/a_3260_375# 0.08663f
C78 gf180mcu_fd_sc_mcu7t5v0__clkbuf_16_1/a_224_552# gf180mcu_fd_sc_mcu7t5v0__fillcap_32_2/a_3260_375# 0
C79 VDD gf180mcu_fd_sc_mcu7t5v0__fillcap_4_2/a_124_375# 0.05707f
C80 VDD gf180mcu_fd_sc_mcu7t5v0__fillcap_16_2/a_1468_375# 0.04221f
C81 gf180mcu_fd_sc_mcu7t5v0__dlyb_1_0/I gf180mcu_fd_sc_mcu7t5v0__dffq_1_1/a_2304_115# 0.09871f
C82 VDD gf180mcu_fd_sc_mcu7t5v0__fillcap_32_5/a_3260_375# -0.0137f
C83 VDD gf180mcu_fd_sc_mcu7t5v0__dffq_1_0/a_880_527# 0
C84 VDD gf180mcu_fd_sc_mcu7t5v0__dffq_1_1/a_2304_115# 0.03044f
C85 clk gf180mcu_fd_sc_mcu7t5v0__fillcap_32_0/a_2364_375# 0
C86 gf180mcu_fd_sc_mcu7t5v0__clkbuf_16_0/a_224_552# gf180mcu_fd_sc_mcu7t5v0__fillcap_32_6/a_36_472# 0.01591f
C87 gf180mcu_fd_sc_mcu7t5v0__fillcap_8_1/a_484_472# gf180mcu_fd_sc_mcu7t5v0__dlyb_1_0/a_671_644# 0.00156f
C88 gf180mcu_fd_sc_mcu7t5v0__dffq_1_1/D gf180mcu_fd_sc_mcu7t5v0__fillcap_16_2/a_484_472# 0.00154f
C89 gf180mcu_fd_sc_mcu7t5v0__dffq_1_1/D gf180mcu_fd_sc_mcu7t5v0__fillcap_4_13/a_36_472# 0
C90 gf180mcu_fd_sc_mcu7t5v0__dffq_1_1/D gf180mcu_fd_sc_mcu7t5v0__xor2_1_0/a_56_604# 0
C91 gf180mcu_fd_sc_mcu7t5v0__dlyb_1_0/a_523_68# gf180mcu_fd_sc_mcu7t5v0__dlyb_1_0/I 0
C92 gf180mcu_fd_sc_mcu7t5v0__dffq_1_2/D gf180mcu_fd_sc_mcu7t5v0__fillcap_16_2/a_1468_375# 0.0017f
C93 VDD gf180mcu_fd_sc_mcu7t5v0__dlyb_1_0/a_523_68# 0
C94 gf180mcu_fd_sc_mcu7t5v0__fillcap_32_1/a_2364_375# gf180mcu_fd_sc_mcu7t5v0__fillcap_32_3/a_2276_472# 0.0027f
C95 gf180mcu_fd_sc_mcu7t5v0__dlyb_1_0/a_47_68# gf180mcu_fd_sc_mcu7t5v0__dffq_1_3/a_2304_115# 0.01089f
C96 gf180mcu_fd_sc_mcu7t5v0__dlyb_1_3/a_895_68# gf180mcu_fd_sc_mcu7t5v0__dffq_1_0/a_2304_115# 0
C97 gf180mcu_fd_sc_mcu7t5v0__dffq_1_3/CLK gf180mcu_fd_sc_mcu7t5v0__dffq_1_1/a_1348_527# 0
C98 gf180mcu_fd_sc_mcu7t5v0__clkbuf_16_2/Z gf180mcu_fd_sc_mcu7t5v0__fillcap_32_5/a_36_472# 0.00123f
C99 gf180mcu_fd_sc_mcu7t5v0__fillcap_16_2/a_572_375# gf180mcu_fd_sc_mcu7t5v0__clkbuf_16_2/a_224_552# 0.03233f
C100 VDD gf180mcu_fd_sc_mcu7t5v0__fillcap_32_3/a_572_375# 0.0152f
C101 gf180mcu_fd_sc_mcu7t5v0__dffq_1_1/a_36_151# gf180mcu_fd_sc_mcu7t5v0__dffq_1_3/a_2304_115# 0
C102 gf180mcu_fd_sc_mcu7t5v0__fillcap_32_0/a_1468_375# gf180mcu_fd_sc_mcu7t5v0__clkbuf_16_2/a_224_552# 0
C103 gf180mcu_fd_sc_mcu7t5v0__clkbuf_16_0/a_224_552# gf180mcu_fd_sc_mcu7t5v0__fillcap_32_6/a_2276_472# 0
C104 gf180mcu_fd_sc_mcu7t5v0__dlyb_1_1/I gf180mcu_fd_sc_mcu7t5v0__fillcap_4_13/a_36_472# 0
C105 gf180mcu_fd_sc_mcu7t5v0__dlyb_1_1/I gf180mcu_fd_sc_mcu7t5v0__xor2_1_0/a_56_604# 0.06371f
C106 gf180mcu_fd_sc_mcu7t5v0__clkbuf_16_1/a_224_552# gf180mcu_fd_sc_mcu7t5v0__fillcap_32_1/a_1020_375# 0.00118f
C107 gf180mcu_fd_sc_mcu7t5v0__fillcap_32_1/a_2364_375# gf180mcu_fd_sc_mcu7t5v0__clkbuf_16_2/Z 0.01407f
C108 gf180mcu_fd_sc_mcu7t5v0__dlyb_1_3/a_671_644# gf180mcu_fd_sc_mcu7t5v0__dlyb_1_3/a_895_68# -0
C109 gf180mcu_fd_sc_mcu7t5v0__fillcap_32_4/a_932_472# gf180mcu_fd_sc_mcu7t5v0__clkbuf_16_2/Z 0.00179f
C110 gf180mcu_fd_sc_mcu7t5v0__dffq_1_1/D gf180mcu_fd_sc_mcu7t5v0__dffq_1_1/a_1348_527# 0
C111 gf180mcu_fd_sc_mcu7t5v0__dffq_1_2/D gf180mcu_fd_sc_mcu7t5v0__dffq_1_2/a_880_527# 0.00112f
C112 VDD gf180mcu_fd_sc_mcu7t5v0__fillcap_32_0/a_932_472# 0.01124f
C113 gf180mcu_fd_sc_mcu7t5v0__nand2_1_0/a_245_68# gf180mcu_fd_sc_mcu7t5v0__fillcap_4_12/a_124_375# 0
C114 gf180mcu_fd_sc_mcu7t5v0__nand2_1_0/a_245_68# gf180mcu_fd_sc_mcu7t5v0__dlyb_1_3/I 0
C115 gf180mcu_fd_sc_mcu7t5v0__fillcap_32_3/a_1020_375# gf180mcu_fd_sc_mcu7t5v0__clkbuf_16_2/Z 0.01203f
C116 gf180mcu_fd_sc_mcu7t5v0__fillcap_16_0/a_124_375# gf180mcu_fd_sc_mcu7t5v0__clkbuf_16_2/Z 0.01591f
C117 gf180mcu_fd_sc_mcu7t5v0__dlyb_1_3/a_671_644# gf180mcu_fd_sc_mcu7t5v0__dffq_1_2/a_2304_115# 0
C118 gf180mcu_fd_sc_mcu7t5v0__fillcap_4_12/a_124_375# gf180mcu_fd_sc_mcu7t5v0__clkbuf_16_2/a_224_552# 0
C119 gf180mcu_fd_sc_mcu7t5v0__dlyb_1_3/I gf180mcu_fd_sc_mcu7t5v0__clkbuf_16_2/a_224_552# 0.01897f
C120 VDD gf180mcu_fd_sc_mcu7t5v0__fillcap_32_6/a_2724_472# -0
C121 gf180mcu_fd_sc_mcu7t5v0__dlyb_1_0/a_671_644# gf180mcu_fd_sc_mcu7t5v0__dffq_1_3/a_2304_115# 0.02792f
C122 gf180mcu_fd_sc_mcu7t5v0__dlyb_1_0/a_47_68# count[1] 0
C123 gf180mcu_fd_sc_mcu7t5v0__xnor2_1_1/a_64_93# gf180mcu_fd_sc_mcu7t5v0__clkbuf_16_2/a_224_552# 0.01192f
C124 gf180mcu_fd_sc_mcu7t5v0__dlyb_1_0/I gf180mcu_fd_sc_mcu7t5v0__xor2_1_0/a_244_604# 0.00104f
C125 VDD gf180mcu_fd_sc_mcu7t5v0__xor2_1_0/a_244_604# 0
C126 gf180mcu_fd_sc_mcu7t5v0__dffq_1_3/CLK gf180mcu_fd_sc_mcu7t5v0__dffq_1_3/a_880_527# 0
C127 gf180mcu_fd_sc_mcu7t5v0__dlyb_1_1/a_895_68# gf180mcu_fd_sc_mcu7t5v0__dlyb_1_1/I 0.01699f
C128 gf180mcu_fd_sc_mcu7t5v0__dffq_1_1/a_36_151# gf180mcu_fd_sc_mcu7t5v0__fillcap_16_2/a_932_472# 0
C129 gf180mcu_fd_sc_mcu7t5v0__fillcap_32_0/a_1380_472# gf180mcu_fd_sc_mcu7t5v0__clkbuf_16_2/Z 0.00724f
C130 gf180mcu_fd_sc_mcu7t5v0__fillcap_32_5/a_1468_375# gf180mcu_fd_sc_mcu7t5v0__clkbuf_16_2/a_224_552# 0.00118f
C131 gf180mcu_fd_sc_mcu7t5v0__fillcap_4_0/a_36_472# gf180mcu_fd_sc_mcu7t5v0__fillcap_4_1/a_124_375# 0.00119f
C132 gf180mcu_fd_sc_mcu7t5v0__dlyb_1_0/I gf180mcu_fd_sc_mcu7t5v0__fillcap_4_6/a_124_375# 0
C133 gf180mcu_fd_sc_mcu7t5v0__fillcap_32_6/a_3172_472# gf180mcu_fd_sc_mcu7t5v0__clkbuf_16_2/Z 0.01557f
C134 VDD gf180mcu_fd_sc_mcu7t5v0__fillcap_4_6/a_124_375# 0.02286f
C135 gf180mcu_fd_sc_mcu7t5v0__nand3_1_0/a_455_68# gf180mcu_fd_sc_mcu7t5v0__dlyb_1_3/I 0
C136 VDD gf180mcu_fd_sc_mcu7t5v0__fillcap_16_1/a_1020_375# 0.05113f
C137 gf180mcu_fd_sc_mcu7t5v0__xor2_1_0/Z gf180mcu_fd_sc_mcu7t5v0__fillcap_16_2/a_484_472# 0.00558f
C138 gf180mcu_fd_sc_mcu7t5v0__xor2_1_0/Z gf180mcu_fd_sc_mcu7t5v0__xor2_1_0/a_56_604# 0.00455f
C139 gf180mcu_fd_sc_mcu7t5v0__dffq_1_2/CLK gf180mcu_fd_sc_mcu7t5v0__dffq_1_2/a_2011_527# 0.00226f
C140 VDD gf180mcu_fd_sc_mcu7t5v0__fillcap_16_0/a_1468_375# -0.0137f
C141 gf180mcu_fd_sc_mcu7t5v0__fillcap_32_1/a_1468_375# gf180mcu_fd_sc_mcu7t5v0__fillcap_32_3/a_1380_472# 0.0027f
C142 clk gf180mcu_fd_sc_mcu7t5v0__fillcap_32_0/a_3172_472# 0.00427f
C143 gf180mcu_fd_sc_mcu7t5v0__dlyb_1_0/a_671_644# count[1] 0
C144 clk gf180mcu_fd_sc_mcu7t5v0__fillcap_32_3/a_2724_472# 0.00416f
C145 VDD clk 0.29155f
C146 gf180mcu_fd_sc_mcu7t5v0__dffq_1_2/a_36_151# gf180mcu_fd_sc_mcu7t5v0__fillcap_32_4/a_36_472# 0
C147 VDD gf180mcu_fd_sc_mcu7t5v0__fillcap_32_4/a_2812_375# 0.00198f
C148 gf180mcu_fd_sc_mcu7t5v0__clkbuf_16_1/a_224_552# gf180mcu_fd_sc_mcu7t5v0__fillcap_8_0/a_484_472# 0
C149 gf180mcu_fd_sc_mcu7t5v0__dlyb_1_0/a_895_68# gf180mcu_fd_sc_mcu7t5v0__fillcap_16_2/a_36_472# 0
C150 gf180mcu_fd_sc_mcu7t5v0__fillcap_16_2/a_484_472# gf180mcu_fd_sc_mcu7t5v0__dffq_1_3/a_448_472# 0.0111f
C151 gf180mcu_fd_sc_mcu7t5v0__fillcap_16_2/a_36_472# gf180mcu_fd_sc_mcu7t5v0__dffq_1_3/a_1376_115# 0
C152 VDD gf180mcu_fd_sc_mcu7t5v0__fillcap_32_0/a_1828_472# 0.01146f
C153 gf180mcu_fd_sc_mcu7t5v0__fillcap_32_0/a_2276_472# gf180mcu_fd_sc_mcu7t5v0__fillcap_32_3/a_2276_472# 0
C154 gf180mcu_fd_sc_mcu7t5v0__fillcap_32_5/a_572_375# gf180mcu_fd_sc_mcu7t5v0__dffq_1_2/a_36_151# 0.00601f
C155 gf180mcu_fd_sc_mcu7t5v0__fillcap_32_6/a_2364_375# gf180mcu_fd_sc_mcu7t5v0__clkbuf_16_2/Z 0
C156 gf180mcu_fd_sc_mcu7t5v0__dffq_1_1/a_2011_527# gf180mcu_fd_sc_mcu7t5v0__dffq_1_3/a_2011_527# 0
C157 gf180mcu_fd_sc_mcu7t5v0__dlyb_1_2/a_503_644# gf180mcu_fd_sc_mcu7t5v0__xnor2_1_0/A2 0
C158 gf180mcu_fd_sc_mcu7t5v0__dlyb_1_0/a_47_68# gf180mcu_fd_sc_mcu7t5v0__dffq_1_3/a_36_151# 0
C159 gf180mcu_fd_sc_mcu7t5v0__dffq_1_3/CLK gf180mcu_fd_sc_mcu7t5v0__fillcap_16_2/a_1380_472# 0.00402f
C160 gf180mcu_fd_sc_mcu7t5v0__fillcap_4_8/a_124_375# gf180mcu_fd_sc_mcu7t5v0__fillcap_32_5/a_3260_375# 0.012f
C161 gf180mcu_fd_sc_mcu7t5v0__dlyb_1_1/a_47_68# gf180mcu_fd_sc_mcu7t5v0__dffq_1_1/D 0.00341f
C162 gf180mcu_fd_sc_mcu7t5v0__dffq_1_3/CLK gf180mcu_fd_sc_mcu7t5v0__clkbuf_16_2/a_224_552# 0.00135f
C163 gf180mcu_fd_sc_mcu7t5v0__dffq_1_1/a_36_151# gf180mcu_fd_sc_mcu7t5v0__dffq_1_3/a_36_151# 0.2014f
C164 gf180mcu_fd_sc_mcu7t5v0__fillcap_16_0/a_36_472# gf180mcu_fd_sc_mcu7t5v0__clkbuf_16_2/Z 0.01014f
C165 gf180mcu_fd_sc_mcu7t5v0__clkbuf_16_0/a_224_552# gf180mcu_fd_sc_mcu7t5v0__fillcap_32_4/a_484_472# 0.001f
C166 gf180mcu_fd_sc_mcu7t5v0__xor2_1_0/Z gf180mcu_fd_sc_mcu7t5v0__dffq_1_1/a_1348_527# 0
C167 gf180mcu_fd_sc_mcu7t5v0__clkbuf_16_0/a_224_552# gf180mcu_fd_sc_mcu7t5v0__dffq_1_2/a_448_472# 0.00271f
C168 gf180mcu_fd_sc_mcu7t5v0__fillcap_32_2/a_2276_472# gf180mcu_fd_sc_mcu7t5v0__clkbuf_16_2/Z 0.0017f
C169 gf180mcu_fd_sc_mcu7t5v0__fillcap_32_0/a_2276_472# gf180mcu_fd_sc_mcu7t5v0__clkbuf_16_2/Z 0.05133f
C170 gf180mcu_fd_sc_mcu7t5v0__clkbuf_16_1/a_224_552# gf180mcu_fd_sc_mcu7t5v0__fillcap_32_2/a_484_472# 0
C171 gf180mcu_fd_sc_mcu7t5v0__dlyb_1_0/I gf180mcu_fd_sc_mcu7t5v0__fillcap_16_2/a_484_472# 0.00372f
C172 gf180mcu_fd_sc_mcu7t5v0__dlyb_1_1/a_47_68# gf180mcu_fd_sc_mcu7t5v0__dlyb_1_1/I 0.19324f
C173 VDD gf180mcu_fd_sc_mcu7t5v0__fillcap_16_2/a_484_472# 0.02224f
C174 VDD gf180mcu_fd_sc_mcu7t5v0__fillcap_32_2/a_932_472# -0
C175 gf180mcu_fd_sc_mcu7t5v0__dffq_1_3/CLK gf180mcu_fd_sc_mcu7t5v0__fillcap_32_2/a_1020_375# 0.00121f
C176 VDD gf180mcu_fd_sc_mcu7t5v0__fillcap_32_5/a_484_472# -0
C177 VDD gf180mcu_fd_sc_mcu7t5v0__fillcap_4_13/a_36_472# 0.10286f
C178 gf180mcu_fd_sc_mcu7t5v0__dlyb_1_0/I gf180mcu_fd_sc_mcu7t5v0__xor2_1_0/a_56_604# 0.04809f
C179 clk gf180mcu_fd_sc_mcu7t5v0__fillcap_32_0/a_2812_375# 0
C180 VDD gf180mcu_fd_sc_mcu7t5v0__xor2_1_0/a_56_604# 0.07386f
C181 gf180mcu_fd_sc_mcu7t5v0__dffq_1_3/CLK gf180mcu_fd_sc_mcu7t5v0__dffq_1_1/a_448_472# 0.01221f
C182 gf180mcu_fd_sc_mcu7t5v0__clkbuf_16_0/a_224_552# gf180mcu_fd_sc_mcu7t5v0__fillcap_32_6/a_932_472# 0.01591f
C183 gf180mcu_fd_sc_mcu7t5v0__dffq_1_3/CLK gf180mcu_fd_sc_mcu7t5v0__dffq_1_1/a_1004_159# 0.00306f
C184 gf180mcu_fd_sc_mcu7t5v0__fillcap_32_1/a_1020_375# gf180mcu_fd_sc_mcu7t5v0__fillcap_32_0/a_1468_375# 0
C185 gf180mcu_fd_sc_mcu7t5v0__nand2_1_0/a_245_68# gf180mcu_fd_sc_mcu7t5v0__dlyb_1_1/I 0.00135f
C186 gf180mcu_fd_sc_mcu7t5v0__dlyb_1_3/a_47_68# gf180mcu_fd_sc_mcu7t5v0__dffq_1_0/D 0.00168f
C187 gf180mcu_fd_sc_mcu7t5v0__fillcap_4_5/a_124_375# gf180mcu_fd_sc_mcu7t5v0__dffq_1_0/D 0
C188 gf180mcu_fd_sc_mcu7t5v0__fillcap_32_0/a_3172_472# gf180mcu_fd_sc_mcu7t5v0__fillcap_32_1/a_2812_375# 0.00168f
C189 gf180mcu_fd_sc_mcu7t5v0__dffq_1_2/D gf180mcu_fd_sc_mcu7t5v0__fillcap_32_5/a_484_472# 0.01324f
C190 VDD gf180mcu_fd_sc_mcu7t5v0__fillcap_32_4/a_1380_472# -0
C191 gf180mcu_fd_sc_mcu7t5v0__fillcap_32_1/a_2812_375# gf180mcu_fd_sc_mcu7t5v0__fillcap_32_3/a_2724_472# 0.0027f
C192 VDD gf180mcu_fd_sc_mcu7t5v0__fillcap_32_1/a_2812_375# 0.02153f
C193 gf180mcu_fd_sc_mcu7t5v0__dlyb_1_1/I gf180mcu_fd_sc_mcu7t5v0__clkbuf_16_2/a_224_552# 0.0133f
C194 gf180mcu_fd_sc_mcu7t5v0__dffq_1_1/D gf180mcu_fd_sc_mcu7t5v0__dffq_1_1/a_448_472# 0.06475f
C195 gf180mcu_fd_sc_mcu7t5v0__dlyb_1_0/I gf180mcu_fd_sc_mcu7t5v0__xnor2_1_1/a_272_93# 0
C196 gf180mcu_fd_sc_mcu7t5v0__dlyb_1_1/a_47_68# gf180mcu_fd_sc_mcu7t5v0__xor2_1_0/a_728_472# 0
C197 gf180mcu_fd_sc_mcu7t5v0__dffq_1_3/CLK gf180mcu_fd_sc_mcu7t5v0__fillcap_8_0/a_572_375# 0.00167f
C198 gf180mcu_fd_sc_mcu7t5v0__dffq_1_1/D gf180mcu_fd_sc_mcu7t5v0__dffq_1_1/a_1004_159# 0.04609f
C199 VDD gf180mcu_fd_sc_mcu7t5v0__fillcap_32_3/a_1468_375# 0.01511f
C200 VDD gf180mcu_fd_sc_mcu7t5v0__xnor2_1_1/a_272_93# 0
C201 gf180mcu_fd_sc_mcu7t5v0__fillcap_32_5/a_3172_472# gf180mcu_fd_sc_mcu7t5v0__fillcap_4_8/a_36_472# 0.01328f
C202 VDD gf180mcu_fd_sc_mcu7t5v0__fillcap_16_0/a_572_375# -0.01464f
C203 gf180mcu_fd_sc_mcu7t5v0__dffq_1_2/CLK gf180mcu_fd_sc_mcu7t5v0__fillcap_32_4/a_1916_375# 0.00241f
C204 VDD gf180mcu_fd_sc_mcu7t5v0__dffq_1_1/a_1348_527# 0
C205 VDD gf180mcu_fd_sc_mcu7t5v0__fillcap_32_6/a_1468_375# 0
C206 gf180mcu_fd_sc_mcu7t5v0__xor2_1_0/Z gf180mcu_fd_sc_mcu7t5v0__dffq_1_3/a_880_527# 0
C207 gf180mcu_fd_sc_mcu7t5v0__fillcap_32_0/a_124_375# gf180mcu_fd_sc_mcu7t5v0__fillcap_32_3/a_36_472# 0.00154f
C208 gf180mcu_fd_sc_mcu7t5v0__dffq_1_2/CLK gf180mcu_fd_sc_mcu7t5v0__fillcap_16_1/a_932_472# 0
C209 gf180mcu_fd_sc_mcu7t5v0__dlyb_1_1/a_895_68# gf180mcu_fd_sc_mcu7t5v0__dlyb_1_0/I 0
C210 VDD gf180mcu_fd_sc_mcu7t5v0__dlyb_1_1/a_895_68# 0
C211 gf180mcu_fd_sc_mcu7t5v0__fillcap_32_0/a_572_375# gf180mcu_fd_sc_mcu7t5v0__clkbuf_16_2/a_224_552# 0
C212 gf180mcu_fd_sc_mcu7t5v0__fillcap_32_1/a_3260_375# gf180mcu_fd_sc_mcu7t5v0__clkbuf_16_2/Z 0.00305f
C213 gf180mcu_fd_sc_mcu7t5v0__fillcap_32_4/a_1828_472# gf180mcu_fd_sc_mcu7t5v0__clkbuf_16_2/Z 0.04412f
C214 gf180mcu_fd_sc_mcu7t5v0__dlyb_1_1/I gf180mcu_fd_sc_mcu7t5v0__dffq_1_1/a_448_472# 0.00248f
C215 gf180mcu_fd_sc_mcu7t5v0__dffq_1_2/D gf180mcu_fd_sc_mcu7t5v0__fillcap_16_0/a_572_375# 0
C216 VDD gf180mcu_fd_sc_mcu7t5v0__fillcap_32_6/a_124_375# 0.00919f
C217 gf180mcu_fd_sc_mcu7t5v0__dffq_1_1/D gf180mcu_fd_sc_mcu7t5v0__fillcap_8_0/a_572_375# 0.00189f
C218 gf180mcu_fd_sc_mcu7t5v0__clkbuf_16_1/a_224_552# gf180mcu_fd_sc_mcu7t5v0__fillcap_32_0/a_1468_375# 0.00222f
C219 gf180mcu_fd_sc_mcu7t5v0__dlyb_1_1/I gf180mcu_fd_sc_mcu7t5v0__dffq_1_1/a_1004_159# 0.00224f
C220 gf180mcu_fd_sc_mcu7t5v0__nand3_1_0/a_455_68# gf180mcu_fd_sc_mcu7t5v0__dlyb_1_1/I 0.00357f
C221 gf180mcu_fd_sc_mcu7t5v0__fillcap_16_0/a_1020_375# gf180mcu_fd_sc_mcu7t5v0__clkbuf_16_2/Z 0.01306f
C222 gf180mcu_fd_sc_mcu7t5v0__dlyb_1_3/a_47_68# gf180mcu_fd_sc_mcu7t5v0__xnor2_1_0/A2 0.07125f
C223 gf180mcu_fd_sc_mcu7t5v0__fillcap_32_1/a_2812_375# gf180mcu_fd_sc_mcu7t5v0__fillcap_32_0/a_2812_375# 0
C224 gf180mcu_fd_sc_mcu7t5v0__xnor2_1_1/A2 gf180mcu_fd_sc_mcu7t5v0__fillcap_16_2/a_484_472# 0.00258f
C225 gf180mcu_fd_sc_mcu7t5v0__fillcap_4_5/a_124_375# gf180mcu_fd_sc_mcu7t5v0__xnor2_1_0/A2 0.00599f
C226 gf180mcu_fd_sc_mcu7t5v0__fillcap_8_1/a_572_375# gf180mcu_fd_sc_mcu7t5v0__dffq_1_3/a_2304_115# 0
C227 gf180mcu_fd_sc_mcu7t5v0__xnor2_1_1/A2 gf180mcu_fd_sc_mcu7t5v0__fillcap_32_5/a_484_472# 0
C228 gf180mcu_fd_sc_mcu7t5v0__fillcap_4_2/a_124_375# gf180mcu_fd_sc_mcu7t5v0__fillcap_4_8/a_36_472# 0.0027f
C229 gf180mcu_fd_sc_mcu7t5v0__fillcap_32_6/a_1916_375# gf180mcu_fd_sc_mcu7t5v0__clkbuf_16_2/Z 0.00162f
C230 gf180mcu_fd_sc_mcu7t5v0__dlyb_1_1/a_47_68# gf180mcu_fd_sc_mcu7t5v0__xor2_1_0/Z 0
C231 gf180mcu_fd_sc_mcu7t5v0__fillcap_4_8/a_36_472# gf180mcu_fd_sc_mcu7t5v0__fillcap_32_5/a_3260_375# 0.08663f
C232 gf180mcu_fd_sc_mcu7t5v0__dffq_1_2/CLK gf180mcu_fd_sc_mcu7t5v0__dffq_1_0/a_880_527# 0
C233 gf180mcu_fd_sc_mcu7t5v0__dlyb_1_1/I gf180mcu_fd_sc_mcu7t5v0__fillcap_8_0/a_572_375# 0.00179f
C234 VDD gf180mcu_fd_sc_mcu7t5v0__fillcap_32_3/a_1916_375# 0.01201f
C235 gf180mcu_fd_sc_mcu7t5v0__dlyb_1_1/a_523_68# gf180mcu_fd_sc_mcu7t5v0__dlyb_1_1/I 0
C236 clk gf180mcu_fd_sc_mcu7t5v0__fillcap_32_5/a_2724_472# 0.01988f
C237 gf180mcu_fd_sc_mcu7t5v0__fillcap_32_2/a_3172_472# gf180mcu_fd_sc_mcu7t5v0__fillcap_4_1/a_36_472# 0.00347f
C238 gf180mcu_fd_sc_mcu7t5v0__dffq_1_1/a_448_472# gf180mcu_fd_sc_mcu7t5v0__xor2_1_0/a_728_472# 0
C239 gf180mcu_fd_sc_mcu7t5v0__xnor2_1_0/a_64_93# gf180mcu_fd_sc_mcu7t5v0__clkbuf_16_0/a_224_552# 0
C240 clk gf180mcu_fd_sc_mcu7t5v0__fillcap_4_8/a_124_375# 0.00613f
C241 VDD gf180mcu_fd_sc_mcu7t5v0__dffq_1_3/a_880_527# 0
C242 gf180mcu_fd_sc_mcu7t5v0__xor2_1_0/a_56_604# gf180mcu_fd_sc_mcu7t5v0__fillcap_4_4/a_124_375# 0.11079f
C243 gf180mcu_fd_sc_mcu7t5v0__xor2_1_0/Z gf180mcu_fd_sc_mcu7t5v0__clkbuf_16_2/a_224_552# 0.00382f
C244 gf180mcu_fd_sc_mcu7t5v0__fillcap_4_5/a_36_472# gf180mcu_fd_sc_mcu7t5v0__dffq_1_0/D 0
C245 VDD gf180mcu_fd_sc_mcu7t5v0__fillcap_32_6/a_2812_375# 0
C246 gf180mcu_fd_sc_mcu7t5v0__xnor2_1_1/A2 gf180mcu_fd_sc_mcu7t5v0__xnor2_1_1/a_272_93# 0.00164f
C247 gf180mcu_fd_sc_mcu7t5v0__xnor2_1_0/A2 gf180mcu_fd_sc_mcu7t5v0__dffq_1_0/D 0.07747f
C248 gf180mcu_fd_sc_mcu7t5v0__dlyb_1_3/I gf180mcu_fd_sc_mcu7t5v0__dffq_1_2/a_36_151# 0.00131f
C249 gf180mcu_fd_sc_mcu7t5v0__fillcap_32_3/a_2364_375# gf180mcu_fd_sc_mcu7t5v0__clkbuf_16_2/Z 0.01291f
C250 gf180mcu_fd_sc_mcu7t5v0__fillcap_32_1/a_1380_472# gf180mcu_fd_sc_mcu7t5v0__clkbuf_16_1/a_224_552# 0.0143f
C251 gf180mcu_fd_sc_mcu7t5v0__dlyb_1_3/a_47_68# gf180mcu_fd_sc_mcu7t5v0__fillcap_4_12/a_124_375# 0
C252 gf180mcu_fd_sc_mcu7t5v0__dlyb_1_3/a_47_68# gf180mcu_fd_sc_mcu7t5v0__dlyb_1_3/I 0.1251f
C253 gf180mcu_fd_sc_mcu7t5v0__dffq_1_3/CLK gf180mcu_fd_sc_mcu7t5v0__fillcap_32_1/a_1020_375# 0
C254 gf180mcu_fd_sc_mcu7t5v0__dffq_1_3/a_448_472# gf180mcu_fd_sc_mcu7t5v0__clkbuf_16_2/a_224_552# 0
C255 VDD gf180mcu_fd_sc_mcu7t5v0__fillcap_16_0/a_484_472# 0
C256 gf180mcu_fd_sc_mcu7t5v0__fillcap_32_4/a_3260_375# gf180mcu_fd_sc_mcu7t5v0__fillcap_4_10/a_36_472# 0.08663f
C257 gf180mcu_fd_sc_mcu7t5v0__dlyb_1_1/a_47_68# gf180mcu_fd_sc_mcu7t5v0__dlyb_1_0/I 0
C258 gf180mcu_fd_sc_mcu7t5v0__fillcap_32_1/a_1916_375# gf180mcu_fd_sc_mcu7t5v0__fillcap_32_3/a_1828_472# 0.0027f
C259 gf180mcu_fd_sc_mcu7t5v0__dffq_1_2/a_448_472# gf180mcu_fd_sc_mcu7t5v0__fillcap_32_4/a_484_472# 0
C260 gf180mcu_fd_sc_mcu7t5v0__dlyb_1_2/a_895_68# gf180mcu_fd_sc_mcu7t5v0__fillcap_4_5/a_36_472# 0.03525f
C261 VDD gf180mcu_fd_sc_mcu7t5v0__dlyb_1_1/a_47_68# 0.06167f
C262 VDD gf180mcu_fd_sc_mcu7t5v0__fillcap_32_2/a_2724_472# -0
C263 VDD gf180mcu_fd_sc_mcu7t5v0__fillcap_32_0/a_2724_472# 0.01119f
C264 gf180mcu_fd_sc_mcu7t5v0__xor2_1_0/Z gf180mcu_fd_sc_mcu7t5v0__dffq_1_1/a_448_472# 0.0921f
C265 gf180mcu_fd_sc_mcu7t5v0__fillcap_16_2/a_484_472# gf180mcu_fd_sc_mcu7t5v0__dffq_1_3/a_1004_159# 0
C266 gf180mcu_fd_sc_mcu7t5v0__fillcap_32_0/a_2724_472# gf180mcu_fd_sc_mcu7t5v0__fillcap_32_3/a_2724_472# 0
C267 gf180mcu_fd_sc_mcu7t5v0__dffq_1_2/a_36_151# gf180mcu_fd_sc_mcu7t5v0__dffq_1_2/a_1376_115# -0
C268 gf180mcu_fd_sc_mcu7t5v0__dlyb_1_3/a_895_68# gf180mcu_fd_sc_mcu7t5v0__fillcap_4_6/a_124_375# 0.02977f
C269 gf180mcu_fd_sc_mcu7t5v0__fillcap_8_1/a_572_375# gf180mcu_fd_sc_mcu7t5v0__fillcap_4_12/a_36_472# 0.08663f
C270 gf180mcu_fd_sc_mcu7t5v0__fillcap_32_6/a_3260_375# gf180mcu_fd_sc_mcu7t5v0__clkbuf_16_2/Z 0
C271 gf180mcu_fd_sc_mcu7t5v0__xor2_1_0/Z gf180mcu_fd_sc_mcu7t5v0__dffq_1_1/a_1004_159# 0.02332f
C272 gf180mcu_fd_sc_mcu7t5v0__dlyb_1_2/a_895_68# gf180mcu_fd_sc_mcu7t5v0__xnor2_1_0/A2 0
C273 gf180mcu_fd_sc_mcu7t5v0__dlyb_1_1/a_671_644# gf180mcu_fd_sc_mcu7t5v0__dffq_1_1/D 0
C274 gf180mcu_fd_sc_mcu7t5v0__dffq_1_2/D gf180mcu_fd_sc_mcu7t5v0__fillcap_16_0/a_484_472# 0
C275 gf180mcu_fd_sc_mcu7t5v0__dlyb_1_2/a_671_644# gf180mcu_fd_sc_mcu7t5v0__xnor2_1_0/a_64_93# 0.00278f
C276 gf180mcu_fd_sc_mcu7t5v0__nand2_1_0/a_245_68# gf180mcu_fd_sc_mcu7t5v0__dlyb_1_0/I 0
C277 VDD gf180mcu_fd_sc_mcu7t5v0__fillcap_4_11/a_124_375# 0.03136f
C278 gf180mcu_fd_sc_mcu7t5v0__dlyb_1_1/a_895_68# gf180mcu_fd_sc_mcu7t5v0__fillcap_4_4/a_124_375# 0.02977f
C279 gf180mcu_fd_sc_mcu7t5v0__dlyb_1_0/I gf180mcu_fd_sc_mcu7t5v0__fillcap_16_2/a_1380_472# 0
C280 VDD gf180mcu_fd_sc_mcu7t5v0__nand2_1_0/a_245_68# 0
C281 gf180mcu_fd_sc_mcu7t5v0__fillcap_16_2/a_1020_375# gf180mcu_fd_sc_mcu7t5v0__dffq_1_3/a_36_151# 0
C282 gf180mcu_fd_sc_mcu7t5v0__dffq_1_1/a_448_472# gf180mcu_fd_sc_mcu7t5v0__dffq_1_3/a_448_472# 0.00114f
C283 VDD gf180mcu_fd_sc_mcu7t5v0__fillcap_16_2/a_1380_472# 0.03373f
C284 VDD gf180mcu_fd_sc_mcu7t5v0__fillcap_32_3/a_3260_375# 0.01432f
C285 gf180mcu_fd_sc_mcu7t5v0__dlyb_1_0/I gf180mcu_fd_sc_mcu7t5v0__clkbuf_16_2/a_224_552# 0.00897f
C286 gf180mcu_fd_sc_mcu7t5v0__dffq_1_1/a_1004_159# gf180mcu_fd_sc_mcu7t5v0__dffq_1_3/a_448_472# 0
C287 gf180mcu_fd_sc_mcu7t5v0__fillcap_32_0/a_3172_472# gf180mcu_fd_sc_mcu7t5v0__clkbuf_16_2/a_224_552# 0
C288 VDD gf180mcu_fd_sc_mcu7t5v0__clkbuf_16_2/a_224_552# 0.1993f
C289 gf180mcu_fd_sc_mcu7t5v0__fillcap_4_5/a_36_472# gf180mcu_fd_sc_mcu7t5v0__xnor2_1_0/A2 0.00489f
C290 gf180mcu_fd_sc_mcu7t5v0__fillcap_32_2/a_3172_472# gf180mcu_fd_sc_mcu7t5v0__clkbuf_16_2/Z 0.0017f
C291 gf180mcu_fd_sc_mcu7t5v0__dlyb_1_3/I gf180mcu_fd_sc_mcu7t5v0__dffq_1_0/D 0.00861f
C292 gf180mcu_fd_sc_mcu7t5v0__dlyb_1_1/a_671_644# gf180mcu_fd_sc_mcu7t5v0__dlyb_1_1/I 0.04706f
C293 gf180mcu_fd_sc_mcu7t5v0__dffq_1_3/CLK gf180mcu_fd_sc_mcu7t5v0__clkbuf_16_1/a_224_552# 0.04493f
C294 VDD gf180mcu_fd_sc_mcu7t5v0__fillcap_32_2/a_1828_472# -0
C295 gf180mcu_fd_sc_mcu7t5v0__dffq_1_0/D gf180mcu_fd_sc_mcu7t5v0__xnor2_1_1/a_64_93# 0
C296 gf180mcu_fd_sc_mcu7t5v0__fillcap_32_1/a_36_472# gf180mcu_fd_sc_mcu7t5v0__dffq_1_1/a_448_472# 0
C297 gf180mcu_fd_sc_mcu7t5v0__dffq_1_2/D gf180mcu_fd_sc_mcu7t5v0__fillcap_16_2/a_1380_472# 0.00102f
C298 gf180mcu_fd_sc_mcu7t5v0__fillcap_4_5/a_124_375# count[3] 0.0025f
C299 gf180mcu_fd_sc_mcu7t5v0__clkbuf_16_1/a_224_552# gf180mcu_fd_sc_mcu7t5v0__fillcap_32_1/a_124_375# 0.00118f
C300 gf180mcu_fd_sc_mcu7t5v0__dffq_1_2/D gf180mcu_fd_sc_mcu7t5v0__clkbuf_16_2/a_224_552# 0.01935f
C301 VDD gf180mcu_fd_sc_mcu7t5v0__fillcap_32_2/a_1020_375# 0
C302 gf180mcu_fd_sc_mcu7t5v0__fillcap_32_1/a_1468_375# gf180mcu_fd_sc_mcu7t5v0__fillcap_32_0/a_1916_375# 0
C303 gf180mcu_fd_sc_mcu7t5v0__dlyb_1_0/I gf180mcu_fd_sc_mcu7t5v0__dffq_1_1/a_448_472# 0.00584f
C304 gf180mcu_fd_sc_mcu7t5v0__xor2_1_0/a_56_604# gf180mcu_fd_sc_mcu7t5v0__dffq_1_1/a_2011_527# 0
C305 VDD gf180mcu_fd_sc_mcu7t5v0__dffq_1_1/a_448_472# 0.06284f
C306 gf180mcu_fd_sc_mcu7t5v0__nand3_1_0/a_455_68# gf180mcu_fd_sc_mcu7t5v0__dlyb_1_0/I 0
C307 VDD gf180mcu_fd_sc_mcu7t5v0__dffq_1_1/a_1004_159# 0.01638f
C308 VDD gf180mcu_fd_sc_mcu7t5v0__fillcap_32_4/a_1020_375# 0.00371f
C309 gf180mcu_fd_sc_mcu7t5v0__dffq_1_1/D gf180mcu_fd_sc_mcu7t5v0__clkbuf_16_1/a_224_552# 0.06099f
C310 gf180mcu_fd_sc_mcu7t5v0__fillcap_32_1/a_3260_375# gf180mcu_fd_sc_mcu7t5v0__fillcap_32_3/a_3172_472# 0.0027f
C311 gf180mcu_fd_sc_mcu7t5v0__dffq_1_2/a_1004_159# gf180mcu_fd_sc_mcu7t5v0__clkbuf_16_2/a_224_552# 0
C312 clk gf180mcu_fd_sc_mcu7t5v0__fillcap_4_8/a_36_472# 0.00661f
C313 gf180mcu_fd_sc_mcu7t5v0__xnor2_1_0/a_64_93# gf180mcu_fd_sc_mcu7t5v0__dlyb_1_2/a_47_68# 0.0184f
C314 gf180mcu_fd_sc_mcu7t5v0__fillcap_32_1/a_3260_375# gf180mcu_fd_sc_mcu7t5v0__fillcap_4_0/a_36_472# 0.08663f
C315 gf180mcu_fd_sc_mcu7t5v0__dffq_1_0/a_36_151# gf180mcu_fd_sc_mcu7t5v0__fillcap_32_4/a_36_472# 0.00482f
C316 gf180mcu_fd_sc_mcu7t5v0__xnor2_1_0/A2 gf180mcu_fd_sc_mcu7t5v0__fillcap_4_12/a_124_375# 0
C317 gf180mcu_fd_sc_mcu7t5v0__dlyb_1_3/I gf180mcu_fd_sc_mcu7t5v0__xnor2_1_0/A2 0.27979f
C318 gf180mcu_fd_sc_mcu7t5v0__xor2_1_0/Z gf180mcu_fd_sc_mcu7t5v0__dffq_1_3/a_2296_527# 0
C319 gf180mcu_fd_sc_mcu7t5v0__fillcap_32_0/a_572_375# gf180mcu_fd_sc_mcu7t5v0__fillcap_32_3/a_484_472# 0.00154f
C320 gf180mcu_fd_sc_mcu7t5v0__dffq_1_0/a_36_151# gf180mcu_fd_sc_mcu7t5v0__dffq_1_2/a_36_151# 0
C321 VDD gf180mcu_fd_sc_mcu7t5v0__fillcap_8_0/a_572_375# 0.04722f
C322 gf180mcu_fd_sc_mcu7t5v0__clkbuf_16_1/a_224_552# gf180mcu_fd_sc_mcu7t5v0__fillcap_32_1/a_2724_472# 0.00104f
C323 gf180mcu_fd_sc_mcu7t5v0__fillcap_16_2/a_1020_375# gf180mcu_fd_sc_mcu7t5v0__clkbuf_16_2/Z 0.00167f
C324 gf180mcu_fd_sc_mcu7t5v0__dlyb_1_1/I gf180mcu_fd_sc_mcu7t5v0__clkbuf_16_1/a_224_552# 0
C325 gf180mcu_fd_sc_mcu7t5v0__dffq_1_0/a_36_151# gf180mcu_fd_sc_mcu7t5v0__dlyb_1_3/a_47_68# 0.0125f
C326 gf180mcu_fd_sc_mcu7t5v0__fillcap_32_4/a_1468_375# gf180mcu_fd_sc_mcu7t5v0__clkbuf_16_2/Z 0.01312f
C327 gf180mcu_fd_sc_mcu7t5v0__nand2_1_0/a_245_68# gf180mcu_fd_sc_mcu7t5v0__xnor2_1_1/A2 0
C328 gf180mcu_fd_sc_mcu7t5v0__dlyb_1_3/a_47_68# gf180mcu_fd_sc_mcu7t5v0__dlyb_1_2/I 0
C329 gf180mcu_fd_sc_mcu7t5v0__fillcap_16_2/a_124_375# gf180mcu_fd_sc_mcu7t5v0__fillcap_4_7/a_124_375# 0
C330 gf180mcu_fd_sc_mcu7t5v0__fillcap_4_5/a_124_375# gf180mcu_fd_sc_mcu7t5v0__dlyb_1_2/I 0.06048f
C331 gf180mcu_fd_sc_mcu7t5v0__fillcap_32_4/a_3260_375# gf180mcu_fd_sc_mcu7t5v0__clkbuf_16_2/Z 0.03223f
C332 gf180mcu_fd_sc_mcu7t5v0__dffq_1_1/D gf180mcu_fd_sc_mcu7t5v0__fillcap_8_0/a_484_472# 0
C333 gf180mcu_fd_sc_mcu7t5v0__clkbuf_16_1/a_224_552# gf180mcu_fd_sc_mcu7t5v0__fillcap_32_0/a_2364_375# 0
C334 gf180mcu_fd_sc_mcu7t5v0__xnor2_1_1/A2 gf180mcu_fd_sc_mcu7t5v0__clkbuf_16_2/a_224_552# 0.07507f
C335 gf180mcu_fd_sc_mcu7t5v0__fillcap_32_5/a_1380_472# gf180mcu_fd_sc_mcu7t5v0__clkbuf_16_2/a_224_552# 0.0143f
C336 gf180mcu_fd_sc_mcu7t5v0__clkbuf_16_0/a_224_552# gf180mcu_fd_sc_mcu7t5v0__dffq_1_0/a_1004_159# 0.00143f
C337 gf180mcu_fd_sc_mcu7t5v0__fillcap_16_0/a_932_472# gf180mcu_fd_sc_mcu7t5v0__clkbuf_16_2/Z 0.01789f
C338 VDD gf180mcu_fd_sc_mcu7t5v0__fillcap_32_4/a_2276_472# -0
C339 gf180mcu_fd_sc_mcu7t5v0__dlyb_1_2/a_895_68# count[3] 0.012f
C340 gf180mcu_fd_sc_mcu7t5v0__fillcap_32_1/a_3260_375# gf180mcu_fd_sc_mcu7t5v0__fillcap_32_0/a_3260_375# 0
C341 gf180mcu_fd_sc_mcu7t5v0__dffq_1_0/a_1348_527# gf180mcu_fd_sc_mcu7t5v0__dffq_1_0/D 0
C342 gf180mcu_fd_sc_mcu7t5v0__clkbuf_16_0/a_224_552# gf180mcu_fd_sc_mcu7t5v0__dffq_1_0/a_448_472# 0.00657f
C343 gf180mcu_fd_sc_mcu7t5v0__fillcap_32_0/a_572_375# gf180mcu_fd_sc_mcu7t5v0__clkbuf_16_1/a_224_552# 0.00222f
C344 gf180mcu_fd_sc_mcu7t5v0__dlyb_1_1/I gf180mcu_fd_sc_mcu7t5v0__dlyb_1_3/a_47_68# 0.02317f
C345 VDD gf180mcu_fd_sc_mcu7t5v0__fillcap_32_2/a_3260_375# 0.03054f
C346 gf180mcu_fd_sc_mcu7t5v0__fillcap_32_0/a_3172_472# gf180mcu_fd_sc_mcu7t5v0__fillcap_32_3/a_2812_375# 0.00154f
C347 VDD gf180mcu_fd_sc_mcu7t5v0__fillcap_32_6/a_1828_472# 0.00285f
C348 gf180mcu_fd_sc_mcu7t5v0__dlyb_1_1/I gf180mcu_fd_sc_mcu7t5v0__fillcap_8_0/a_484_472# 0.00115f
C349 VDD gf180mcu_fd_sc_mcu7t5v0__fillcap_32_3/a_2812_375# 0.01345f
C350 gf180mcu_fd_sc_mcu7t5v0__fillcap_4_5/a_36_472# count[3] 0.00514f
C351 gf180mcu_fd_sc_mcu7t5v0__clkbuf_16_0/a_224_552# gf180mcu_fd_sc_mcu7t5v0__clkbuf_16_2/Z 0.06659f
C352 gf180mcu_fd_sc_mcu7t5v0__fillcap_32_1/a_1380_472# gf180mcu_fd_sc_mcu7t5v0__fillcap_32_0/a_1468_375# 0.00168f
C353 VDD gf180mcu_fd_sc_mcu7t5v0__fillcap_32_3/a_932_472# 0.01856f
C354 count[2] gf180mcu_fd_sc_mcu7t5v0__fillcap_4_6/a_36_472# 0.00604f
C355 gf180mcu_fd_sc_mcu7t5v0__fillcap_8_1/a_36_472# gf180mcu_fd_sc_mcu7t5v0__dlyb_1_1/I 0.01439f
C356 gf180mcu_fd_sc_mcu7t5v0__dffq_1_0/a_36_151# gf180mcu_fd_sc_mcu7t5v0__dffq_1_0/D 0.04633f
C357 gf180mcu_fd_sc_mcu7t5v0__dlyb_1_2/I gf180mcu_fd_sc_mcu7t5v0__dffq_1_0/D 0.0142f
C358 gf180mcu_fd_sc_mcu7t5v0__dlyb_1_0/I gf180mcu_fd_sc_mcu7t5v0__dffq_1_3/a_2296_527# 0
C359 gf180mcu_fd_sc_mcu7t5v0__fillcap_32_4/a_2724_472# gf180mcu_fd_sc_mcu7t5v0__clkbuf_16_2/Z 0.00577f
C360 VDD gf180mcu_fd_sc_mcu7t5v0__dffq_1_3/a_2296_527# 0
C361 gf180mcu_fd_sc_mcu7t5v0__clkbuf_16_0/a_224_552# gf180mcu_fd_sc_mcu7t5v0__xnor2_1_0/a_716_68# 0
C362 gf180mcu_fd_sc_mcu7t5v0__dlyb_1_3/I gf180mcu_fd_sc_mcu7t5v0__xnor2_1_1/a_64_93# 0.06124f
C363 gf180mcu_fd_sc_mcu7t5v0__dffq_1_2/CLK gf180mcu_fd_sc_mcu7t5v0__fillcap_32_4/a_1380_472# 0.01229f
C364 gf180mcu_fd_sc_mcu7t5v0__dlyb_1_2/a_503_644# VDD 0
C365 gf180mcu_fd_sc_mcu7t5v0__dffq_1_1/D gf180mcu_fd_sc_mcu7t5v0__dffq_1_3/a_1328_159# 0
C366 gf180mcu_fd_sc_mcu7t5v0__fillcap_16_2/a_124_375# gf180mcu_fd_sc_mcu7t5v0__dffq_1_3/a_36_151# 0
C367 gf180mcu_fd_sc_mcu7t5v0__dffq_1_0/a_1328_159# gf180mcu_fd_sc_mcu7t5v0__dffq_1_0/D 0
C368 gf180mcu_fd_sc_mcu7t5v0__dlyb_1_3/I gf180mcu_fd_sc_mcu7t5v0__dffq_1_2/a_1376_115# 0.00114f
C369 gf180mcu_fd_sc_mcu7t5v0__fillcap_32_6/a_2276_472# gf180mcu_fd_sc_mcu7t5v0__clkbuf_16_2/Z 0.01557f
C370 gf180mcu_fd_sc_mcu7t5v0__dffq_1_2/CLK gf180mcu_fd_sc_mcu7t5v0__fillcap_16_0/a_572_375# 0
C371 gf180mcu_fd_sc_mcu7t5v0__fillcap_32_1/a_2276_472# gf180mcu_fd_sc_mcu7t5v0__clkbuf_16_1/a_224_552# 0.00104f
C372 gf180mcu_fd_sc_mcu7t5v0__fillcap_32_5/a_2724_472# gf180mcu_fd_sc_mcu7t5v0__clkbuf_16_2/a_224_552# 0.00104f
C373 gf180mcu_fd_sc_mcu7t5v0__dffq_1_3/a_1004_159# gf180mcu_fd_sc_mcu7t5v0__clkbuf_16_2/a_224_552# 0
C374 gf180mcu_fd_sc_mcu7t5v0__fillcap_32_3/a_1380_472# gf180mcu_fd_sc_mcu7t5v0__clkbuf_16_2/Z 0.01324f
C375 gf180mcu_fd_sc_mcu7t5v0__dffq_1_0/a_1348_527# gf180mcu_fd_sc_mcu7t5v0__xnor2_1_0/A2 0
C376 gf180mcu_fd_sc_mcu7t5v0__dlyb_1_2/a_895_68# gf180mcu_fd_sc_mcu7t5v0__dlyb_1_2/I 0.01427f
C377 gf180mcu_fd_sc_mcu7t5v0__dlyb_1_1/a_671_644# gf180mcu_fd_sc_mcu7t5v0__dlyb_1_0/I 0.01194f
C378 gf180mcu_fd_sc_mcu7t5v0__xor2_1_0/Z gf180mcu_fd_sc_mcu7t5v0__clkbuf_16_1/a_224_552# 0.01464f
C379 VDD gf180mcu_fd_sc_mcu7t5v0__dlyb_1_1/a_671_644# 0.01172f
C380 gf180mcu_fd_sc_mcu7t5v0__dlyb_1_3/I gf180mcu_fd_sc_mcu7t5v0__dffq_1_2/a_2296_527# 0
C381 VDD gf180mcu_fd_sc_mcu7t5v0__fillcap_32_1/a_1020_375# 0.02153f
C382 gf180mcu_fd_sc_mcu7t5v0__fillcap_8_1/a_484_472# gf180mcu_fd_sc_mcu7t5v0__fillcap_4_12/a_36_472# 0.01328f
C383 gf180mcu_fd_sc_mcu7t5v0__dffq_1_3/CLK gf180mcu_fd_sc_mcu7t5v0__fillcap_32_0/a_1468_375# 0
C384 gf180mcu_fd_sc_mcu7t5v0__dlyb_1_0/a_47_68# gf180mcu_fd_sc_mcu7t5v0__dffq_1_3/a_2011_527# 0.00699f
C385 gf180mcu_fd_sc_mcu7t5v0__fillcap_4_5/a_36_472# gf180mcu_fd_sc_mcu7t5v0__dlyb_1_2/I 0.0212f
C386 gf180mcu_fd_sc_mcu7t5v0__clkbuf_16_1/a_224_552# gf180mcu_fd_sc_mcu7t5v0__dffq_1_3/a_448_472# 0
C387 gf180mcu_fd_sc_mcu7t5v0__dffq_1_0/a_36_151# gf180mcu_fd_sc_mcu7t5v0__xnor2_1_0/A2 0.04464f
C388 gf180mcu_fd_sc_mcu7t5v0__dlyb_1_2/I gf180mcu_fd_sc_mcu7t5v0__xnor2_1_0/A2 0.12868f
C389 gf180mcu_fd_sc_mcu7t5v0__dffq_1_1/a_36_151# gf180mcu_fd_sc_mcu7t5v0__dffq_1_3/a_2011_527# 0.00106f
C390 VDD gf180mcu_fd_sc_mcu7t5v0__fillcap_32_3/a_484_472# 0.01856f
C391 gf180mcu_fd_sc_mcu7t5v0__fillcap_16_2/a_572_375# gf180mcu_fd_sc_mcu7t5v0__dffq_1_1/D 0
C392 gf180mcu_fd_sc_mcu7t5v0__dffq_1_0/a_1328_159# gf180mcu_fd_sc_mcu7t5v0__xnor2_1_0/A2 0
C393 gf180mcu_fd_sc_mcu7t5v0__fillcap_32_1/a_1468_375# gf180mcu_fd_sc_mcu7t5v0__clkbuf_16_2/Z 0.01312f
C394 gf180mcu_fd_sc_mcu7t5v0__fillcap_32_1/a_36_472# gf180mcu_fd_sc_mcu7t5v0__clkbuf_16_1/a_224_552# 0.0143f
C395 gf180mcu_fd_sc_mcu7t5v0__dlyb_1_1/I gf180mcu_fd_sc_mcu7t5v0__xnor2_1_0/A2 0.015f
C396 gf180mcu_fd_sc_mcu7t5v0__dffq_1_0/a_1348_527# gf180mcu_fd_sc_mcu7t5v0__dlyb_1_3/I 0
C397 gf180mcu_fd_sc_mcu7t5v0__dlyb_1_0/I gf180mcu_fd_sc_mcu7t5v0__clkbuf_16_1/a_224_552# 0.00528f
C398 VDD gf180mcu_fd_sc_mcu7t5v0__clkbuf_16_1/a_224_552# 0.17519f
C399 gf180mcu_fd_sc_mcu7t5v0__fillcap_32_1/a_1916_375# gf180mcu_fd_sc_mcu7t5v0__fillcap_32_0/a_2364_375# 0
C400 VDD gf180mcu_fd_sc_mcu7t5v0__fillcap_32_5/a_1916_375# -0.01464f
C401 gf180mcu_fd_sc_mcu7t5v0__fillcap_4_13/a_124_375# gf180mcu_fd_sc_mcu7t5v0__fillcap_4_13/a_36_472# 0
C402 gf180mcu_fd_sc_mcu7t5v0__dlyb_1_0/a_895_68# gf180mcu_fd_sc_mcu7t5v0__fillcap_8_1/a_572_375# 0
C403 gf180mcu_fd_sc_mcu7t5v0__dlyb_1_2/a_47_68# gf180mcu_fd_sc_mcu7t5v0__dffq_1_0/a_448_472# 0
C404 gf180mcu_fd_sc_mcu7t5v0__dlyb_1_0/a_47_68# gf180mcu_fd_sc_mcu7t5v0__dffq_1_1/a_2304_115# 0.00115f
C405 gf180mcu_fd_sc_mcu7t5v0__dlyb_1_0/a_671_644# gf180mcu_fd_sc_mcu7t5v0__dffq_1_3/a_2011_527# 0.00142f
C406 count[1] gf180mcu_fd_sc_mcu7t5v0__dffq_1_3/a_2304_115# 0
C407 gf180mcu_fd_sc_mcu7t5v0__dffq_1_3/CLK gf180mcu_fd_sc_mcu7t5v0__fillcap_32_1/a_1380_472# 0.00107f
C408 gf180mcu_fd_sc_mcu7t5v0__dffq_1_0/a_36_151# gf180mcu_fd_sc_mcu7t5v0__dlyb_1_3/I 0.00498f
C409 VDD gf180mcu_fd_sc_mcu7t5v0__fillcap_32_4/a_36_472# 0.11021f
C410 gf180mcu_fd_sc_mcu7t5v0__dlyb_1_2/I gf180mcu_fd_sc_mcu7t5v0__dlyb_1_3/I 0.00198f
C411 gf180mcu_fd_sc_mcu7t5v0__dlyb_1_0/I gf180mcu_fd_sc_mcu7t5v0__dlyb_1_3/a_47_68# 0.01258f
C412 gf180mcu_fd_sc_mcu7t5v0__dffq_1_2/a_2304_115# gf180mcu_fd_sc_mcu7t5v0__clkbuf_16_2/a_224_552# 0
C413 VDD gf180mcu_fd_sc_mcu7t5v0__dffq_1_2/a_36_151# 0.0956f
C414 gf180mcu_fd_sc_mcu7t5v0__clkbuf_16_2/a_224_552# gf180mcu_fd_sc_mcu7t5v0__fillcap_32_0/a_36_472# 0.00229f
C415 VDD gf180mcu_fd_sc_mcu7t5v0__fillcap_32_5/a_572_375# 0.01655f
C416 gf180mcu_fd_sc_mcu7t5v0__fillcap_32_5/a_1916_375# gf180mcu_fd_sc_mcu7t5v0__dffq_1_2/D 0
C417 gf180mcu_fd_sc_mcu7t5v0__dffq_1_2/CLK gf180mcu_fd_sc_mcu7t5v0__fillcap_16_0/a_484_472# 0.00222f
C418 VDD gf180mcu_fd_sc_mcu7t5v0__fillcap_16_0/a_1380_472# -0
C419 gf180mcu_fd_sc_mcu7t5v0__dffq_1_0/a_36_151# gf180mcu_fd_sc_mcu7t5v0__xnor2_1_1/a_64_93# 0
C420 VDD gf180mcu_fd_sc_mcu7t5v0__dlyb_1_3/a_47_68# 0.02085f
C421 gf180mcu_fd_sc_mcu7t5v0__fillcap_4_7/a_36_472# gf180mcu_fd_sc_mcu7t5v0__xnor2_1_0/A2 0.00884f
C422 gf180mcu_fd_sc_mcu7t5v0__fillcap_16_1/a_124_375# gf180mcu_fd_sc_mcu7t5v0__dffq_1_0/D 0.00453f
C423 VDD gf180mcu_fd_sc_mcu7t5v0__fillcap_4_5/a_124_375# 0.02709f
C424 gf180mcu_fd_sc_mcu7t5v0__xor2_1_0/Z gf180mcu_fd_sc_mcu7t5v0__dffq_1_3/a_1328_159# 0
C425 gf180mcu_fd_sc_mcu7t5v0__dlyb_1_3/a_47_68# gf180mcu_fd_sc_mcu7t5v0__dffq_1_0/a_2011_527# 0
C426 gf180mcu_fd_sc_mcu7t5v0__fillcap_32_5/a_2364_375# gf180mcu_fd_sc_mcu7t5v0__clkbuf_16_2/Z 0.01291f
C427 gf180mcu_fd_sc_mcu7t5v0__dffq_1_0/a_1328_159# gf180mcu_fd_sc_mcu7t5v0__dlyb_1_3/I 0
C428 VDD gf180mcu_fd_sc_mcu7t5v0__fillcap_8_0/a_484_472# 0.02368f
C429 gf180mcu_fd_sc_mcu7t5v0__dffq_1_2/D gf180mcu_fd_sc_mcu7t5v0__fillcap_32_4/a_36_472# 0.00316f
C430 gf180mcu_fd_sc_mcu7t5v0__dlyb_1_2/a_47_68# gf180mcu_fd_sc_mcu7t5v0__xnor2_1_0/a_716_68# 0
C431 gf180mcu_fd_sc_mcu7t5v0__fillcap_8_1/a_36_472# gf180mcu_fd_sc_mcu7t5v0__dlyb_1_0/I 0
C432 gf180mcu_fd_sc_mcu7t5v0__dlyb_1_1/I gf180mcu_fd_sc_mcu7t5v0__fillcap_4_12/a_124_375# 0.04196f
C433 gf180mcu_fd_sc_mcu7t5v0__dlyb_1_1/I gf180mcu_fd_sc_mcu7t5v0__dlyb_1_3/I 0.03313f
C434 VDD gf180mcu_fd_sc_mcu7t5v0__fillcap_32_6/a_484_472# -0
C435 VDD gf180mcu_fd_sc_mcu7t5v0__fillcap_8_1/a_36_472# 0.10241f
C436 gf180mcu_fd_sc_mcu7t5v0__dffq_1_2/D gf180mcu_fd_sc_mcu7t5v0__dffq_1_2/a_36_151# 0.04562f
C437 gf180mcu_fd_sc_mcu7t5v0__fillcap_32_0/a_484_472# gf180mcu_fd_sc_mcu7t5v0__clkbuf_16_2/a_224_552# 0.00221f
C438 gf180mcu_fd_sc_mcu7t5v0__fillcap_32_5/a_572_375# gf180mcu_fd_sc_mcu7t5v0__dffq_1_2/D 0.01066f
C439 gf180mcu_fd_sc_mcu7t5v0__clkbuf_16_1/a_224_552# gf180mcu_fd_sc_mcu7t5v0__fillcap_32_0/a_2812_375# 0
C440 gf180mcu_fd_sc_mcu7t5v0__dffq_1_2/a_448_472# gf180mcu_fd_sc_mcu7t5v0__clkbuf_16_2/Z 0
C441 gf180mcu_fd_sc_mcu7t5v0__fillcap_32_5/a_1020_375# gf180mcu_fd_sc_mcu7t5v0__clkbuf_16_2/Z 0.01085f
C442 gf180mcu_fd_sc_mcu7t5v0__dlyb_1_0/a_671_644# gf180mcu_fd_sc_mcu7t5v0__dffq_1_1/a_2304_115# 0.00131f
C443 VDD gf180mcu_fd_sc_mcu7t5v0__fillcap_32_4/a_3172_472# -0
C444 gf180mcu_fd_sc_mcu7t5v0__dffq_1_2/CLK gf180mcu_fd_sc_mcu7t5v0__clkbuf_16_2/a_224_552# 0
C445 gf180mcu_fd_sc_mcu7t5v0__dffq_1_2/a_1004_159# gf180mcu_fd_sc_mcu7t5v0__fillcap_32_4/a_36_472# 0.00175f
C446 gf180mcu_fd_sc_mcu7t5v0__dlyb_1_2/a_671_644# gf180mcu_fd_sc_mcu7t5v0__fillcap_16_1/a_36_472# 0
C447 count[3] gf180mcu_fd_sc_mcu7t5v0__dlyb_1_2/I 0.00152f
C448 VDD gf180mcu_fd_sc_mcu7t5v0__dffq_1_0/D 0.29631f
C449 VDD gf180mcu_fd_sc_mcu7t5v0__fillcap_32_2/a_484_472# -0
C450 gf180mcu_fd_sc_mcu7t5v0__dffq_1_3/CLK gf180mcu_fd_sc_mcu7t5v0__fillcap_32_1/a_124_375# 0.00832f
C451 gf180mcu_fd_sc_mcu7t5v0__dffq_1_0/a_2011_527# gf180mcu_fd_sc_mcu7t5v0__dffq_1_0/D 0
C452 gf180mcu_fd_sc_mcu7t5v0__fillcap_32_1/a_1828_472# gf180mcu_fd_sc_mcu7t5v0__fillcap_32_0/a_1916_375# 0.00168f
C453 count[1] gf180mcu_fd_sc_mcu7t5v0__fillcap_4_6/a_36_472# 0
C454 VDD gf180mcu_fd_sc_mcu7t5v0__fillcap_32_3/a_1828_472# 0.01596f
C455 gf180mcu_fd_sc_mcu7t5v0__fillcap_4_7/a_36_472# gf180mcu_fd_sc_mcu7t5v0__dlyb_1_3/I 0.00765f
C456 gf180mcu_fd_sc_mcu7t5v0__dlyb_1_0/I gf180mcu_fd_sc_mcu7t5v0__dffq_1_3/a_1328_159# 0
C457 gf180mcu_fd_sc_mcu7t5v0__fillcap_16_2/a_572_375# gf180mcu_fd_sc_mcu7t5v0__xor2_1_0/Z 0.00525f
C458 VDD gf180mcu_fd_sc_mcu7t5v0__dffq_1_3/a_1328_159# 0
C459 clk gf180mcu_fd_sc_mcu7t5v0__fillcap_32_0/a_2276_472# 0.00227f
C460 gf180mcu_fd_sc_mcu7t5v0__dffq_1_3/CLK gf180mcu_fd_sc_mcu7t5v0__dffq_1_1/D 0.05708f
C461 gf180mcu_fd_sc_mcu7t5v0__fillcap_4_7/a_36_472# gf180mcu_fd_sc_mcu7t5v0__xnor2_1_1/a_64_93# 0.00685f
C462 gf180mcu_fd_sc_mcu7t5v0__dffq_1_2/CLK gf180mcu_fd_sc_mcu7t5v0__fillcap_32_4/a_1020_375# 0.04852f
C463 gf180mcu_fd_sc_mcu7t5v0__xnor2_1_1/A2 gf180mcu_fd_sc_mcu7t5v0__dffq_1_2/a_36_151# 0.00344f
C464 gf180mcu_fd_sc_mcu7t5v0__dlyb_1_2/a_895_68# VDD 0.00752f
C465 VDD gf180mcu_fd_sc_mcu7t5v0__fillcap_4_2/a_36_472# 0.10865f
C466 gf180mcu_fd_sc_mcu7t5v0__fillcap_32_5/a_572_375# gf180mcu_fd_sc_mcu7t5v0__xnor2_1_1/A2 0
C467 gf180mcu_fd_sc_mcu7t5v0__dlyb_1_2/a_895_68# gf180mcu_fd_sc_mcu7t5v0__dffq_1_0/a_2011_527# 0
C468 gf180mcu_fd_sc_mcu7t5v0__dlyb_1_2/a_671_644# gf180mcu_fd_sc_mcu7t5v0__dffq_1_0/a_2304_115# 0
C469 VDD gf180mcu_fd_sc_mcu7t5v0__dffq_1_2/a_2256_159# 0.00169f
C470 gf180mcu_fd_sc_mcu7t5v0__dffq_1_0/a_836_159# gf180mcu_fd_sc_mcu7t5v0__xnor2_1_0/A2 0
C471 gf180mcu_fd_sc_mcu7t5v0__fillcap_32_0/a_124_375# gf180mcu_fd_sc_mcu7t5v0__dffq_1_3/a_36_151# 0.00631f
C472 gf180mcu_fd_sc_mcu7t5v0__xnor2_1_0/A2 gf180mcu_fd_sc_mcu7t5v0__dlyb_1_0/a_503_644# 0
C473 VDD gf180mcu_fd_sc_mcu7t5v0__fillcap_4_5/a_36_472# 0.10431f
C474 gf180mcu_fd_sc_mcu7t5v0__dlyb_1_1/I gf180mcu_fd_sc_mcu7t5v0__dffq_1_3/CLK 0
C475 gf180mcu_fd_sc_mcu7t5v0__dlyb_1_0/I gf180mcu_fd_sc_mcu7t5v0__xnor2_1_0/A2 0.00523f
C476 gf180mcu_fd_sc_mcu7t5v0__dffq_1_0/a_36_151# gf180mcu_fd_sc_mcu7t5v0__dlyb_1_2/I 0.01296f
C477 VDD gf180mcu_fd_sc_mcu7t5v0__xnor2_1_0/A2 0.30187f
C478 gf180mcu_fd_sc_mcu7t5v0__dffq_1_3/a_36_151# gf180mcu_fd_sc_mcu7t5v0__fillcap_16_2/a_932_472# 0.01149f
C479 VDD gf180mcu_fd_sc_mcu7t5v0__fillcap_32_1/a_1916_375# 0.02066f
C480 count[1] gf180mcu_fd_sc_mcu7t5v0__dffq_1_3/a_36_151# 0
C481 gf180mcu_fd_sc_mcu7t5v0__nand3_1_0/a_271_68# gf180mcu_fd_sc_mcu7t5v0__fillcap_4_6/a_124_375# 0
C482 gf180mcu_fd_sc_mcu7t5v0__dlyb_1_1/a_1147_68# gf180mcu_fd_sc_mcu7t5v0__dlyb_1_1/I 0
C483 gf180mcu_fd_sc_mcu7t5v0__dffq_1_0/a_2011_527# gf180mcu_fd_sc_mcu7t5v0__xnor2_1_0/A2 0.06688f
C484 gf180mcu_fd_sc_mcu7t5v0__dlyb_1_1/a_671_644# gf180mcu_fd_sc_mcu7t5v0__dffq_1_1/a_2011_527# 0
C485 gf180mcu_fd_sc_mcu7t5v0__dlyb_1_2/a_47_68# gf180mcu_fd_sc_mcu7t5v0__fillcap_16_1/a_36_472# 0.17126f
C486 gf180mcu_fd_sc_mcu7t5v0__clkbuf_16_1/a_224_552# gf180mcu_fd_sc_mcu7t5v0__dffq_1_3/a_1004_159# 0
C487 gf180mcu_fd_sc_mcu7t5v0__fillcap_16_2/a_572_375# gf180mcu_fd_sc_mcu7t5v0__dlyb_1_0/I 0.00416f
C488 gf180mcu_fd_sc_mcu7t5v0__fillcap_32_0/a_572_375# gf180mcu_fd_sc_mcu7t5v0__dffq_1_3/CLK 0.00377f
C489 VDD gf180mcu_fd_sc_mcu7t5v0__fillcap_16_2/a_572_375# 0.01953f
C490 VDD gf180mcu_fd_sc_mcu7t5v0__fillcap_32_0/a_1468_375# 0.02336f
C491 gf180mcu_fd_sc_mcu7t5v0__fillcap_32_4/a_1380_472# gf180mcu_fd_sc_mcu7t5v0__fillcap_16_0/a_36_472# 0.05841f
C492 gf180mcu_fd_sc_mcu7t5v0__dlyb_1_1/I gf180mcu_fd_sc_mcu7t5v0__dffq_1_1/D 0.04966f
C493 gf180mcu_fd_sc_mcu7t5v0__xnor2_1_0/a_64_93# gf180mcu_fd_sc_mcu7t5v0__dffq_1_0/a_448_472# 0.01037f
C494 gf180mcu_fd_sc_mcu7t5v0__xnor2_1_1/A2 gf180mcu_fd_sc_mcu7t5v0__dffq_1_0/D 0
C495 gf180mcu_fd_sc_mcu7t5v0__fillcap_32_0/a_572_375# gf180mcu_fd_sc_mcu7t5v0__fillcap_32_1/a_124_375# 0
C496 gf180mcu_fd_sc_mcu7t5v0__fillcap_16_2/a_1468_375# gf180mcu_fd_sc_mcu7t5v0__fillcap_32_3/a_36_472# 0.01227f
C497 gf180mcu_fd_sc_mcu7t5v0__fillcap_32_0/a_2724_472# gf180mcu_fd_sc_mcu7t5v0__fillcap_32_1/a_2364_375# 0.00168f
C498 gf180mcu_fd_sc_mcu7t5v0__dffq_1_3/CLK gf180mcu_fd_sc_mcu7t5v0__xor2_1_0/a_728_472# 0
C499 gf180mcu_fd_sc_mcu7t5v0__fillcap_32_1/a_932_472# gf180mcu_fd_sc_mcu7t5v0__clkbuf_16_1/a_224_552# 0.0143f
C500 gf180mcu_fd_sc_mcu7t5v0__clkbuf_16_2/a_224_552# gf180mcu_fd_sc_mcu7t5v0__fillcap_32_5/a_36_472# 0.0143f
C501 clk gf180mcu_fd_sc_mcu7t5v0__fillcap_16_0/a_1020_375# 0
C502 gf180mcu_fd_sc_mcu7t5v0__dlyb_1_2/a_523_68# gf180mcu_fd_sc_mcu7t5v0__xnor2_1_0/A2 0
C503 gf180mcu_fd_sc_mcu7t5v0__fillcap_16_1/a_1468_375# gf180mcu_fd_sc_mcu7t5v0__fillcap_32_6/a_124_375# 0.00544f
C504 gf180mcu_fd_sc_mcu7t5v0__fillcap_32_2/a_3260_375# gf180mcu_fd_sc_mcu7t5v0__fillcap_4_1/a_124_375# 0.00544f
C505 gf180mcu_fd_sc_mcu7t5v0__fillcap_32_2/a_2364_375# gf180mcu_fd_sc_mcu7t5v0__clkbuf_16_1/a_224_552# 0
C506 gf180mcu_fd_sc_mcu7t5v0__fillcap_32_0/a_1916_375# gf180mcu_fd_sc_mcu7t5v0__clkbuf_16_2/Z 0.03077f
C507 gf180mcu_fd_sc_mcu7t5v0__dlyb_1_0/I gf180mcu_fd_sc_mcu7t5v0__fillcap_4_12/a_124_375# 0.06374f
C508 count[2] gf180mcu_fd_sc_mcu7t5v0__dffq_1_0/a_2304_115# 0
C509 gf180mcu_fd_sc_mcu7t5v0__dlyb_1_0/I gf180mcu_fd_sc_mcu7t5v0__dlyb_1_3/I 0.03787f
C510 VDD gf180mcu_fd_sc_mcu7t5v0__fillcap_4_12/a_124_375# 0.01456f
C511 gf180mcu_fd_sc_mcu7t5v0__fillcap_4_3/a_36_472# gf180mcu_fd_sc_mcu7t5v0__dlyb_1_1/I 0.01307f
C512 VDD gf180mcu_fd_sc_mcu7t5v0__fillcap_32_5/a_2812_375# -0.01464f
C513 gf180mcu_fd_sc_mcu7t5v0__fillcap_4_7/a_124_375# gf180mcu_fd_sc_mcu7t5v0__dffq_1_0/a_1004_159# 0
C514 VDD gf180mcu_fd_sc_mcu7t5v0__dlyb_1_3/I 0.50929f
C515 gf180mcu_fd_sc_mcu7t5v0__dffq_1_1/D gf180mcu_fd_sc_mcu7t5v0__xor2_1_0/a_728_472# 0.00391f
C516 gf180mcu_fd_sc_mcu7t5v0__dlyb_1_0/I gf180mcu_fd_sc_mcu7t5v0__xnor2_1_1/a_64_93# 0.0024f
C517 gf180mcu_fd_sc_mcu7t5v0__dffq_1_0/a_2011_527# gf180mcu_fd_sc_mcu7t5v0__dlyb_1_3/I 0
C518 VDD gf180mcu_fd_sc_mcu7t5v0__xnor2_1_1/a_64_93# 0.02421f
C519 gf180mcu_fd_sc_mcu7t5v0__dffq_1_1/a_36_151# gf180mcu_fd_sc_mcu7t5v0__fillcap_16_2/a_484_472# 0
C520 gf180mcu_fd_sc_mcu7t5v0__dffq_1_0/a_448_472# gf180mcu_fd_sc_mcu7t5v0__fillcap_4_7/a_124_375# 0
C521 gf180mcu_fd_sc_mcu7t5v0__clkbuf_16_0/a_224_552# gf180mcu_fd_sc_mcu7t5v0__fillcap_32_4/a_1916_375# 0.00137f
C522 VDD gf180mcu_fd_sc_mcu7t5v0__fillcap_4_10/a_124_375# 0.04453f
C523 gf180mcu_fd_sc_mcu7t5v0__clkbuf_16_0/a_224_552# gf180mcu_fd_sc_mcu7t5v0__fillcap_16_1/a_932_472# 0.01591f
C524 gf180mcu_fd_sc_mcu7t5v0__fillcap_32_3/a_1020_375# gf180mcu_fd_sc_mcu7t5v0__clkbuf_16_2/a_224_552# 0.02641f
C525 gf180mcu_fd_sc_mcu7t5v0__clkbuf_16_2/a_224_552# gf180mcu_fd_sc_mcu7t5v0__fillcap_16_0/a_124_375# 0
C526 gf180mcu_fd_sc_mcu7t5v0__dffq_1_3/CLK gf180mcu_fd_sc_mcu7t5v0__xor2_1_0/Z 0.02273f
C527 gf180mcu_fd_sc_mcu7t5v0__dlyb_1_3/a_671_644# count[2] 0.00991f
C528 VDD gf180mcu_fd_sc_mcu7t5v0__dffq_1_2/a_1376_115# 0.00715f
C529 gf180mcu_fd_sc_mcu7t5v0__xnor2_1_1/A2 gf180mcu_fd_sc_mcu7t5v0__xnor2_1_0/A2 0
C530 gf180mcu_fd_sc_mcu7t5v0__dffq_1_2/D gf180mcu_fd_sc_mcu7t5v0__dlyb_1_3/I 0.0054f
C531 VDD gf180mcu_fd_sc_mcu7t5v0__fillcap_32_5/a_1468_375# -0.01464f
C532 VDD gf180mcu_fd_sc_mcu7t5v0__fillcap_32_1/a_1380_472# 0.00336f
C533 gf180mcu_fd_sc_mcu7t5v0__fillcap_8_1/a_124_375# count[2] 0
C534 gf180mcu_fd_sc_mcu7t5v0__dlyb_1_1/I gf180mcu_fd_sc_mcu7t5v0__xor2_1_0/a_728_472# 0.02698f
C535 gf180mcu_fd_sc_mcu7t5v0__dffq_1_2/D gf180mcu_fd_sc_mcu7t5v0__xnor2_1_1/a_64_93# 0.00147f
C536 VDD gf180mcu_fd_sc_mcu7t5v0__dffq_1_2/a_2296_527# 0.00222f
C537 gf180mcu_fd_sc_mcu7t5v0__dlyb_1_1/I gf180mcu_fd_sc_mcu7t5v0__fillcap_4_7/a_36_472# 0.04531f
C538 clk gf180mcu_fd_sc_mcu7t5v0__fillcap_32_3/a_2364_375# 0.02965f
C539 gf180mcu_fd_sc_mcu7t5v0__dffq_1_3/CLK gf180mcu_fd_sc_mcu7t5v0__dffq_1_3/a_448_472# 0.00889f
C540 gf180mcu_fd_sc_mcu7t5v0__fillcap_32_0/a_484_472# gf180mcu_fd_sc_mcu7t5v0__fillcap_32_3/a_484_472# 0
C541 gf180mcu_fd_sc_mcu7t5v0__fillcap_16_2/a_572_375# gf180mcu_fd_sc_mcu7t5v0__xnor2_1_1/A2 0.00327f
C542 gf180mcu_fd_sc_mcu7t5v0__dffq_1_0/D gf180mcu_fd_sc_mcu7t5v0__fillcap_16_1/a_484_472# 0.00406f
C543 gf180mcu_fd_sc_mcu7t5v0__fillcap_32_0/a_2276_472# gf180mcu_fd_sc_mcu7t5v0__fillcap_32_3/a_1916_375# 0.00154f
C544 gf180mcu_fd_sc_mcu7t5v0__dffq_1_2/D gf180mcu_fd_sc_mcu7t5v0__dffq_1_2/a_1376_115# 0.01106f
C545 gf180mcu_fd_sc_mcu7t5v0__fillcap_4_10/a_36_472# gf180mcu_fd_sc_mcu7t5v0__clkbuf_16_2/Z 0
C546 gf180mcu_fd_sc_mcu7t5v0__clkbuf_16_1/a_224_552# gf180mcu_fd_sc_mcu7t5v0__fillcap_32_0/a_36_472# 0
C547 gf180mcu_fd_sc_mcu7t5v0__fillcap_32_0/a_1380_472# gf180mcu_fd_sc_mcu7t5v0__clkbuf_16_2/a_224_552# 0.00221f
C548 gf180mcu_fd_sc_mcu7t5v0__fillcap_32_5/a_1468_375# gf180mcu_fd_sc_mcu7t5v0__dffq_1_2/D 0.00243f
C549 gf180mcu_fd_sc_mcu7t5v0__dlyb_1_3/I gf180mcu_fd_sc_mcu7t5v0__dffq_1_2/a_1004_159# 0.00103f
C550 gf180mcu_fd_sc_mcu7t5v0__fillcap_4_13/a_124_375# gf180mcu_fd_sc_mcu7t5v0__fillcap_8_0/a_572_375# 0.012f
C551 gf180mcu_fd_sc_mcu7t5v0__xor2_1_0/Z gf180mcu_fd_sc_mcu7t5v0__dffq_1_1/D 0.08372f
C552 gf180mcu_fd_sc_mcu7t5v0__clkbuf_16_2/a_224_552# gf180mcu_fd_sc_mcu7t5v0__fillcap_32_5/a_124_375# 0.00118f
C553 VDD count[3] 0.15852f
C554 gf180mcu_fd_sc_mcu7t5v0__fillcap_4_3/a_124_375# gf180mcu_fd_sc_mcu7t5v0__dffq_1_3/a_2304_115# 0.00628f
C555 gf180mcu_fd_sc_mcu7t5v0__fillcap_32_1/a_1828_472# gf180mcu_fd_sc_mcu7t5v0__clkbuf_16_2/Z 0.05146f
C556 gf180mcu_fd_sc_mcu7t5v0__dffq_1_2/D gf180mcu_fd_sc_mcu7t5v0__dffq_1_2/a_2296_527# 0
C557 gf180mcu_fd_sc_mcu7t5v0__fillcap_4_5/a_124_375# gf180mcu_fd_sc_mcu7t5v0__dlyb_1_3/a_895_68# 0.00163f
C558 gf180mcu_fd_sc_mcu7t5v0__dffq_1_3/CLK gf180mcu_fd_sc_mcu7t5v0__fillcap_32_1/a_36_472# 0.01324f
C559 gf180mcu_fd_sc_mcu7t5v0__dffq_1_1/D gf180mcu_fd_sc_mcu7t5v0__dffq_1_3/a_448_472# 0.00181f
C560 gf180mcu_fd_sc_mcu7t5v0__fillcap_16_1/a_124_375# gf180mcu_fd_sc_mcu7t5v0__dlyb_1_2/I 0.00627f
C561 gf180mcu_fd_sc_mcu7t5v0__clkbuf_16_1/a_224_552# gf180mcu_fd_sc_mcu7t5v0__fillcap_32_0/a_484_472# 0
C562 gf180mcu_fd_sc_mcu7t5v0__dlyb_1_0/a_895_68# gf180mcu_fd_sc_mcu7t5v0__dffq_1_3/a_2304_115# 0
C563 gf180mcu_fd_sc_mcu7t5v0__dlyb_1_3/a_47_68# gf180mcu_fd_sc_mcu7t5v0__dffq_1_2/a_2304_115# 0
C564 gf180mcu_fd_sc_mcu7t5v0__xnor2_1_1/A2 gf180mcu_fd_sc_mcu7t5v0__fillcap_4_12/a_124_375# 0
C565 gf180mcu_fd_sc_mcu7t5v0__dlyb_1_1/I gf180mcu_fd_sc_mcu7t5v0__xor2_1_0/Z 0.02492f
C566 gf180mcu_fd_sc_mcu7t5v0__dlyb_1_3/a_671_644# gf180mcu_fd_sc_mcu7t5v0__fillcap_8_1/a_484_472# 0.00242f
C567 gf180mcu_fd_sc_mcu7t5v0__fillcap_32_1/a_2276_472# gf180mcu_fd_sc_mcu7t5v0__fillcap_32_0/a_2364_375# 0.00168f
C568 VDD gf180mcu_fd_sc_mcu7t5v0__dffq_1_3/CLK 0.39218f
C569 gf180mcu_fd_sc_mcu7t5v0__xnor2_1_1/A2 gf180mcu_fd_sc_mcu7t5v0__dlyb_1_3/I 0.20528f
C570 gf180mcu_fd_sc_mcu7t5v0__fillcap_4_3/a_36_472# gf180mcu_fd_sc_mcu7t5v0__xor2_1_0/Z 0
C571 VDD gf180mcu_fd_sc_mcu7t5v0__dffq_1_0/a_1348_527# 0
C572 gf180mcu_fd_sc_mcu7t5v0__dffq_1_3/a_36_151# gf180mcu_fd_sc_mcu7t5v0__clkbuf_16_2/Z 0
C573 gf180mcu_fd_sc_mcu7t5v0__xnor2_1_1/A2 gf180mcu_fd_sc_mcu7t5v0__xnor2_1_1/a_64_93# 0.04629f
C574 VDD gf180mcu_fd_sc_mcu7t5v0__fillcap_32_1/a_124_375# 0.03284f
C575 gf180mcu_fd_sc_mcu7t5v0__dlyb_1_1/I gf180mcu_fd_sc_mcu7t5v0__dffq_1_3/a_448_472# 0
C576 gf180mcu_fd_sc_mcu7t5v0__fillcap_32_0/a_572_375# gf180mcu_fd_sc_mcu7t5v0__xor2_1_0/Z 0
C577 gf180mcu_fd_sc_mcu7t5v0__xnor2_1_0/a_930_497# gf180mcu_fd_sc_mcu7t5v0__dffq_1_0/D 0.0043f
C578 gf180mcu_fd_sc_mcu7t5v0__dlyb_1_0/I gf180mcu_fd_sc_mcu7t5v0__dffq_1_1/D 0.0062f
C579 gf180mcu_fd_sc_mcu7t5v0__fillcap_4_3/a_36_472# gf180mcu_fd_sc_mcu7t5v0__dffq_1_3/a_448_472# 0
C580 gf180mcu_fd_sc_mcu7t5v0__dlyb_1_0/I gf180mcu_fd_sc_mcu7t5v0__dffq_1_0/a_36_151# 0
C581 gf180mcu_fd_sc_mcu7t5v0__dffq_1_2/CLK gf180mcu_fd_sc_mcu7t5v0__fillcap_32_4/a_36_472# 0.01138f
C582 VDD gf180mcu_fd_sc_mcu7t5v0__dffq_1_1/D 0.21509f
C583 VDD gf180mcu_fd_sc_mcu7t5v0__dffq_1_0/a_36_151# 0.15516f
C584 gf180mcu_fd_sc_mcu7t5v0__dffq_1_2/CLK gf180mcu_fd_sc_mcu7t5v0__dffq_1_2/a_36_151# 0.04186f
C585 gf180mcu_fd_sc_mcu7t5v0__fillcap_16_0/a_36_472# gf180mcu_fd_sc_mcu7t5v0__clkbuf_16_2/a_224_552# 0
C586 VDD gf180mcu_fd_sc_mcu7t5v0__fillcap_4_9/a_124_375# 0.01577f
C587 VDD gf180mcu_fd_sc_mcu7t5v0__dlyb_1_2/I 0.29172f
C588 gf180mcu_fd_sc_mcu7t5v0__fillcap_4_3/a_124_375# count[1] 0.0221f
C589 gf180mcu_fd_sc_mcu7t5v0__dffq_1_2/CLK gf180mcu_fd_sc_mcu7t5v0__fillcap_16_0/a_1380_472# 0
C590 gf180mcu_fd_sc_mcu7t5v0__xor2_1_0/Z gf180mcu_fd_sc_mcu7t5v0__xor2_1_0/a_728_472# 0.00136f
C591 gf180mcu_fd_sc_mcu7t5v0__dffq_1_0/a_2011_527# gf180mcu_fd_sc_mcu7t5v0__dlyb_1_2/I 0.01039f
C592 gf180mcu_fd_sc_mcu7t5v0__dffq_1_0/D gf180mcu_fd_sc_mcu7t5v0__dffq_1_2/a_2304_115# 0.00296f
C593 gf180mcu_fd_sc_mcu7t5v0__fillcap_32_0/a_2276_472# gf180mcu_fd_sc_mcu7t5v0__clkbuf_16_2/a_224_552# 0
C594 gf180mcu_fd_sc_mcu7t5v0__fillcap_32_1/a_572_375# gf180mcu_fd_sc_mcu7t5v0__clkbuf_16_2/Z 0.00241f
C595 gf180mcu_fd_sc_mcu7t5v0__fillcap_32_3/a_2276_472# gf180mcu_fd_sc_mcu7t5v0__clkbuf_16_2/Z 0.01784f
C596 gf180mcu_fd_sc_mcu7t5v0__dlyb_1_0/a_895_68# count[1] 0.01773f
C597 gf180mcu_fd_sc_mcu7t5v0__dlyb_1_1/I gf180mcu_fd_sc_mcu7t5v0__dlyb_1_0/a_503_644# 0
C598 VDD gf180mcu_fd_sc_mcu7t5v0__dffq_1_0/a_1328_159# 0
C599 gf180mcu_fd_sc_mcu7t5v0__dffq_1_2/CLK gf180mcu_fd_sc_mcu7t5v0__fillcap_32_6/a_484_472# 0
C600 gf180mcu_fd_sc_mcu7t5v0__fillcap_32_3/a_124_375# gf180mcu_fd_sc_mcu7t5v0__clkbuf_16_2/Z 0.0021f
C601 VDD gf180mcu_fd_sc_mcu7t5v0__fillcap_32_1/a_2724_472# 0.00336f
C602 gf180mcu_fd_sc_mcu7t5v0__dlyb_1_1/I gf180mcu_fd_sc_mcu7t5v0__dlyb_1_0/I 0.85999f
C603 gf180mcu_fd_sc_mcu7t5v0__dffq_1_2/D gf180mcu_fd_sc_mcu7t5v0__dffq_1_0/a_36_151# 0
C604 gf180mcu_fd_sc_mcu7t5v0__clkbuf_16_0/a_224_552# gf180mcu_fd_sc_mcu7t5v0__fillcap_32_6/a_2724_472# 0
C605 VDD gf180mcu_fd_sc_mcu7t5v0__dlyb_1_1/I 0.8256f
C606 gf180mcu_fd_sc_mcu7t5v0__fillcap_4_3/a_36_472# gf180mcu_fd_sc_mcu7t5v0__dlyb_1_0/I 0.0067f
C607 VDD gf180mcu_fd_sc_mcu7t5v0__fillcap_4_3/a_36_472# 0.10865f
C608 gf180mcu_fd_sc_mcu7t5v0__xnor2_1_0/a_64_93# gf180mcu_fd_sc_mcu7t5v0__dffq_1_0/a_2304_115# 0
C609 gf180mcu_fd_sc_mcu7t5v0__fillcap_4_9/a_36_472# gf180mcu_fd_sc_mcu7t5v0__clkbuf_16_2/Z 0.00252f
C610 VDD gf180mcu_fd_sc_mcu7t5v0__fillcap_32_0/a_2364_375# 0.02336f
C611 gf180mcu_fd_sc_mcu7t5v0__fillcap_32_4/a_1828_472# gf180mcu_fd_sc_mcu7t5v0__fillcap_16_0/a_484_472# 0.05841f
C612 gf180mcu_fd_sc_mcu7t5v0__dlyb_1_1/a_47_68# gf180mcu_fd_sc_mcu7t5v0__dffq_1_1/a_36_151# 0
C613 gf180mcu_fd_sc_mcu7t5v0__xnor2_1_0/a_930_497# gf180mcu_fd_sc_mcu7t5v0__xnor2_1_0/A2 0.00493f
C614 gf180mcu_fd_sc_mcu7t5v0__fillcap_32_0/a_1380_472# gf180mcu_fd_sc_mcu7t5v0__fillcap_32_3/a_932_472# 0
C615 gf180mcu_fd_sc_mcu7t5v0__dlyb_1_2/a_523_68# gf180mcu_fd_sc_mcu7t5v0__dlyb_1_2/I 0
C616 gf180mcu_fd_sc_mcu7t5v0__fillcap_32_0/a_1020_375# gf180mcu_fd_sc_mcu7t5v0__fillcap_32_1/a_572_375# 0
C617 VDD gf180mcu_fd_sc_mcu7t5v0__fillcap_32_0/a_572_375# 0.02336f
C618 gf180mcu_fd_sc_mcu7t5v0__dlyb_1_3/a_895_68# gf180mcu_fd_sc_mcu7t5v0__xnor2_1_0/A2 0.00444f
C619 gf180mcu_fd_sc_mcu7t5v0__dffq_1_2/CLK gf180mcu_fd_sc_mcu7t5v0__dffq_1_0/D 0.07563f
C620 gf180mcu_fd_sc_mcu7t5v0__fillcap_32_1/a_3172_472# gf180mcu_fd_sc_mcu7t5v0__clkbuf_16_2/Z 0.0155f
C621 gf180mcu_fd_sc_mcu7t5v0__xnor2_1_0/a_64_93# gf180mcu_fd_sc_mcu7t5v0__dlyb_1_3/a_671_644# 0
C622 gf180mcu_fd_sc_mcu7t5v0__dlyb_1_1/I gf180mcu_fd_sc_mcu7t5v0__dffq_1_1/a_2296_527# 0
C623 clk gf180mcu_fd_sc_mcu7t5v0__fillcap_16_0/a_932_472# 0
C624 gf180mcu_fd_sc_mcu7t5v0__clkbuf_16_0/a_224_552# gf180mcu_fd_sc_mcu7t5v0__fillcap_16_1/a_1020_375# 0
C625 gf180mcu_fd_sc_mcu7t5v0__dlyb_1_0/I gf180mcu_fd_sc_mcu7t5v0__fillcap_4_7/a_36_472# 0.105f
C626 VDD gf180mcu_fd_sc_mcu7t5v0__xor2_1_0/a_728_472# 0.00873f
C627 gf180mcu_fd_sc_mcu7t5v0__dffq_1_1/a_36_151# gf180mcu_fd_sc_mcu7t5v0__fillcap_16_2/a_1380_472# 0
C628 gf180mcu_fd_sc_mcu7t5v0__xnor2_1_0/A2 gf180mcu_fd_sc_mcu7t5v0__dffq_1_2/a_2304_115# 0.00155f
C629 gf180mcu_fd_sc_mcu7t5v0__xor2_1_0/Z gf180mcu_fd_sc_mcu7t5v0__dffq_1_3/a_448_472# 0.06925f
C630 VDD gf180mcu_fd_sc_mcu7t5v0__fillcap_4_7/a_36_472# 0.07014f
C631 gf180mcu_fd_sc_mcu7t5v0__fillcap_32_1/a_2724_472# gf180mcu_fd_sc_mcu7t5v0__fillcap_32_0/a_2812_375# 0.00168f
C632 gf180mcu_fd_sc_mcu7t5v0__xnor2_1_1/A2 gf180mcu_fd_sc_mcu7t5v0__dffq_1_0/a_36_151# 0
C633 gf180mcu_fd_sc_mcu7t5v0__clkbuf_16_1/a_224_552# gf180mcu_fd_sc_mcu7t5v0__fillcap_4_13/a_124_375# 0.03233f
C634 gf180mcu_fd_sc_mcu7t5v0__fillcap_32_0/a_1020_375# gf180mcu_fd_sc_mcu7t5v0__clkbuf_16_2/Z 0.00332f
C635 gf180mcu_fd_sc_mcu7t5v0__clkbuf_16_0/a_224_552# gf180mcu_fd_sc_mcu7t5v0__fillcap_32_4/a_2812_375# 0.00137f
C636 gf180mcu_fd_sc_mcu7t5v0__dffq_1_3/a_36_151# gf180mcu_fd_sc_mcu7t5v0__dffq_1_3/a_1376_115# 0
C637 gf180mcu_fd_sc_mcu7t5v0__fillcap_16_1/a_572_375# gf180mcu_fd_sc_mcu7t5v0__dffq_1_0/D 0.00213f
C638 gf180mcu_fd_sc_mcu7t5v0__dlyb_1_3/a_523_68# count[2] 0
C639 gf180mcu_fd_sc_mcu7t5v0__fillcap_32_0/a_1380_472# gf180mcu_fd_sc_mcu7t5v0__fillcap_32_1/a_1020_375# 0.00168f
C640 gf180mcu_fd_sc_mcu7t5v0__dffq_1_2/D gf180mcu_fd_sc_mcu7t5v0__fillcap_4_7/a_36_472# 0
C641 gf180mcu_fd_sc_mcu7t5v0__fillcap_32_5/a_932_472# gf180mcu_fd_sc_mcu7t5v0__clkbuf_16_2/Z 0.00928f
C642 gf180mcu_fd_sc_mcu7t5v0__xnor2_1_1/a_716_68# gf180mcu_fd_sc_mcu7t5v0__clkbuf_16_2/a_224_552# 0.00133f
C643 gf180mcu_fd_sc_mcu7t5v0__fillcap_32_2/a_1916_375# gf180mcu_fd_sc_mcu7t5v0__fillcap_32_1/a_1828_472# 0
C644 VDD gf180mcu_fd_sc_mcu7t5v0__fillcap_32_1/a_2276_472# 0.00336f
C645 gf180mcu_fd_sc_mcu7t5v0__dffq_1_2/a_36_151# gf180mcu_fd_sc_mcu7t5v0__fillcap_32_5/a_36_472# 0.00168f
C646 gf180mcu_fd_sc_mcu7t5v0__xnor2_1_0/a_930_497# gf180mcu_fd_sc_mcu7t5v0__dlyb_1_3/I 0
C647 gf180mcu_fd_sc_mcu7t5v0__dlyb_1_3/a_671_644# gf180mcu_fd_sc_mcu7t5v0__fillcap_4_12/a_36_472# 0
C648 gf180mcu_fd_sc_mcu7t5v0__dlyb_1_0/I gf180mcu_fd_sc_mcu7t5v0__xor2_1_0/Z 0.09242f
C649 gf180mcu_fd_sc_mcu7t5v0__fillcap_8_1/a_124_375# count[1] 0.00397f
C650 gf180mcu_fd_sc_mcu7t5v0__dlyb_1_1/I gf180mcu_fd_sc_mcu7t5v0__xnor2_1_1/A2 0.03252f
C651 gf180mcu_fd_sc_mcu7t5v0__dlyb_1_3/a_895_68# gf180mcu_fd_sc_mcu7t5v0__dlyb_1_3/I 0.02644f
C652 VDD gf180mcu_fd_sc_mcu7t5v0__xor2_1_0/Z 0.32851f
C653 gf180mcu_fd_sc_mcu7t5v0__dffq_1_2/CLK gf180mcu_fd_sc_mcu7t5v0__xnor2_1_0/A2 0.00146f
C654 gf180mcu_fd_sc_mcu7t5v0__dffq_1_3/CLK gf180mcu_fd_sc_mcu7t5v0__dffq_1_3/a_1004_159# 0.00135f
C655 gf180mcu_fd_sc_mcu7t5v0__fillcap_32_0/a_2724_472# gf180mcu_fd_sc_mcu7t5v0__fillcap_32_3/a_2364_375# 0.00154f
C656 gf180mcu_fd_sc_mcu7t5v0__dlyb_1_3/I gf180mcu_fd_sc_mcu7t5v0__dffq_1_2/a_2304_115# 0.04883f
C657 gf180mcu_fd_sc_mcu7t5v0__dlyb_1_0/I gf180mcu_fd_sc_mcu7t5v0__dffq_1_3/a_448_472# 0.00789f
C658 gf180mcu_fd_sc_mcu7t5v0__fillcap_32_0/a_1828_472# gf180mcu_fd_sc_mcu7t5v0__fillcap_32_3/a_1380_472# 0
C659 VDD gf180mcu_fd_sc_mcu7t5v0__fillcap_16_1/a_124_375# 0.00981f
C660 gf180mcu_fd_sc_mcu7t5v0__dffq_1_2/a_36_151# gf180mcu_fd_sc_mcu7t5v0__fillcap_32_4/a_932_472# 0.00108f
C661 gf180mcu_fd_sc_mcu7t5v0__dlyb_1_1/I gf180mcu_fd_sc_mcu7t5v0__fillcap_4_4/a_124_375# 0.02604f
C662 VDD gf180mcu_fd_sc_mcu7t5v0__dffq_1_3/a_448_472# 0.08022f
C663 gf180mcu_fd_sc_mcu7t5v0__dffq_1_2/a_2304_115# gf180mcu_fd_sc_mcu7t5v0__xnor2_1_1/a_64_93# 0
C664 gf180mcu_fd_sc_mcu7t5v0__dffq_1_2/D gf180mcu_fd_sc_mcu7t5v0__dffq_1_2/a_1328_159# 0
C665 gf180mcu_fd_sc_mcu7t5v0__dffq_1_3/CLK gf180mcu_fd_sc_mcu7t5v0__fillcap_32_1/a_932_472# 0.00237f
C666 gf180mcu_fd_sc_mcu7t5v0__dffq_1_2/a_36_151# gf180mcu_fd_sc_mcu7t5v0__fillcap_16_0/a_124_375# 0.00576f
C667 gf180mcu_fd_sc_mcu7t5v0__xor2_1_0/Z gf180mcu_fd_sc_mcu7t5v0__dffq_1_1/a_2296_527# 0
C668 gf180mcu_fd_sc_mcu7t5v0__dffq_1_1/D gf180mcu_fd_sc_mcu7t5v0__dffq_1_3/a_1004_159# 0.00482f
C669 gf180mcu_fd_sc_mcu7t5v0__dffq_1_0/a_1004_159# gf180mcu_fd_sc_mcu7t5v0__fillcap_16_1/a_36_472# 0
C670 gf180mcu_fd_sc_mcu7t5v0__clkbuf_16_1/a_224_552# gf180mcu_fd_sc_mcu7t5v0__fillcap_32_0/a_1380_472# 0
C671 gf180mcu_fd_sc_mcu7t5v0__fillcap_4_0/a_36_472# gf180mcu_fd_sc_mcu7t5v0__fillcap_4_1/a_36_472# 0
C672 gf180mcu_fd_sc_mcu7t5v0__fillcap_32_3/a_2364_375# gf180mcu_fd_sc_mcu7t5v0__clkbuf_16_2/a_224_552# 0.00137f
C673 gf180mcu_fd_sc_mcu7t5v0__xnor2_1_1/A2 gf180mcu_fd_sc_mcu7t5v0__fillcap_4_7/a_36_472# 0.00944f
C674 VDD gf180mcu_fd_sc_mcu7t5v0__fillcap_32_1/a_36_472# 0.10934f
C675 gf180mcu_fd_sc_mcu7t5v0__dffq_1_0/a_448_472# gf180mcu_fd_sc_mcu7t5v0__fillcap_16_1/a_36_472# 0
C676 gf180mcu_fd_sc_mcu7t5v0__clkbuf_16_0/a_224_552# gf180mcu_fd_sc_mcu7t5v0__fillcap_32_4/a_1380_472# 0.001f
C677 gf180mcu_fd_sc_mcu7t5v0__dlyb_1_2/I gf180mcu_fd_sc_mcu7t5v0__fillcap_16_1/a_484_472# 0.00182f
C678 gf180mcu_fd_sc_mcu7t5v0__fillcap_32_6/a_3260_375# gf180mcu_fd_sc_mcu7t5v0__fillcap_4_11/a_124_375# 0.00544f
C679 gf180mcu_fd_sc_mcu7t5v0__dlyb_1_0/I gf180mcu_fd_sc_mcu7t5v0__dlyb_1_0/a_503_644# 0
C680 VDD gf180mcu_fd_sc_mcu7t5v0__dffq_1_0/a_836_159# 0
C681 VDD gf180mcu_fd_sc_mcu7t5v0__dlyb_1_0/a_503_644# 0
C682 gf180mcu_fd_sc_mcu7t5v0__fillcap_32_5/a_2276_472# gf180mcu_fd_sc_mcu7t5v0__clkbuf_16_2/Z 0.01784f
C683 gf180mcu_fd_sc_mcu7t5v0__fillcap_32_2/a_36_472# gf180mcu_fd_sc_mcu7t5v0__fillcap_4_13/a_36_472# 0.00347f
C684 VDD gf180mcu_fd_sc_mcu7t5v0__dlyb_1_0/I 0.59784f
C685 count[1] gf180mcu_fd_sc_mcu7t5v0__fillcap_4_4/a_36_472# 0.00106f
C686 gf180mcu_fd_sc_mcu7t5v0__fillcap_32_0/a_3172_472# gf180mcu_fd_sc_mcu7t5v0__fillcap_32_3/a_2724_472# 0
C687 VDD gf180mcu_fd_sc_mcu7t5v0__fillcap_32_3/a_2724_472# 0.01856f
C688 VDD gf180mcu_fd_sc_mcu7t5v0__fillcap_32_0/a_3172_472# 0.01627f
C689 gf180mcu_fd_sc_mcu7t5v0__fillcap_32_0/a_1828_472# gf180mcu_fd_sc_mcu7t5v0__fillcap_32_1/a_1468_375# 0.00168f
C690 gf180mcu_fd_sc_mcu7t5v0__fillcap_32_4/a_36_472# gf180mcu_fd_sc_mcu7t5v0__fillcap_32_5/a_124_375# 0.00227f
C691 gf180mcu_fd_sc_mcu7t5v0__dffq_1_2/a_36_151# gf180mcu_fd_sc_mcu7t5v0__fillcap_32_5/a_124_375# 0.00153f
C692 gf180mcu_fd_sc_mcu7t5v0__dffq_1_0/a_1376_115# gf180mcu_fd_sc_mcu7t5v0__dffq_1_0/D 0.00898f
C693 VDD gf180mcu_fd_sc_mcu7t5v0__dffq_1_0/a_2011_527# 0.00641f
C694 gf180mcu_fd_sc_mcu7t5v0__clkbuf_16_0/a_224_552# gf180mcu_fd_sc_mcu7t5v0__fillcap_32_6/a_1468_375# 0
C695 gf180mcu_fd_sc_mcu7t5v0__dlyb_1_2/a_1127_622# gf180mcu_fd_sc_mcu7t5v0__fillcap_16_1/a_36_472# 0
C696 gf180mcu_fd_sc_mcu7t5v0__fillcap_32_1/a_484_472# gf180mcu_fd_sc_mcu7t5v0__clkbuf_16_2/Z 0.00187f
C697 count[2] gf180mcu_fd_sc_mcu7t5v0__fillcap_4_6/a_124_375# 0.00397f
C698 gf180mcu_fd_sc_mcu7t5v0__dffq_1_2/CLK gf180mcu_fd_sc_mcu7t5v0__dffq_1_2/a_1376_115# 0.00399f
C699 gf180mcu_fd_sc_mcu7t5v0__fillcap_32_6/a_1828_472# gf180mcu_fd_sc_mcu7t5v0__fillcap_32_4/a_1828_472# 0
C700 gf180mcu_fd_sc_mcu7t5v0__dffq_1_0/a_36_151# gf180mcu_fd_sc_mcu7t5v0__fillcap_32_4/a_124_375# 0.00119f
C701 gf180mcu_fd_sc_mcu7t5v0__fillcap_32_6/a_124_375# gf180mcu_fd_sc_mcu7t5v0__fillcap_32_6/a_36_472# -0
C702 gf180mcu_fd_sc_mcu7t5v0__xor2_1_0/Z gf180mcu_fd_sc_mcu7t5v0__xnor2_1_1/A2 0
C703 gf180mcu_fd_sc_mcu7t5v0__dffq_1_3/CLK gf180mcu_fd_sc_mcu7t5v0__dffq_1_1/a_1328_159# 0
C704 VDD gf180mcu_fd_sc_mcu7t5v0__dffq_1_2/D 0.42386f
C705 gf180mcu_fd_sc_mcu7t5v0__clkbuf_16_0/a_224_552# gf180mcu_fd_sc_mcu7t5v0__fillcap_32_6/a_124_375# 0
C706 gf180mcu_fd_sc_mcu7t5v0__dffq_1_1/D gf180mcu_fd_sc_mcu7t5v0__dffq_1_1/a_2011_527# 0
C707 gf180mcu_fd_sc_mcu7t5v0__fillcap_32_2/a_1916_375# gf180mcu_fd_sc_mcu7t5v0__clkbuf_16_2/Z 0.03f
C708 gf180mcu_fd_sc_mcu7t5v0__dlyb_1_0/I gf180mcu_fd_sc_mcu7t5v0__dffq_1_1/a_2296_527# 0
C709 gf180mcu_fd_sc_mcu7t5v0__dffq_1_1/a_2304_115# gf180mcu_fd_sc_mcu7t5v0__dffq_1_3/a_2304_115# 0.00157f
C710 VDD gf180mcu_fd_sc_mcu7t5v0__dffq_1_1/a_2296_527# 0
C711 gf180mcu_fd_sc_mcu7t5v0__fillcap_32_3/a_3172_472# gf180mcu_fd_sc_mcu7t5v0__clkbuf_16_2/Z 0.00247f
C712 gf180mcu_fd_sc_mcu7t5v0__dffq_1_3/CLK gf180mcu_fd_sc_mcu7t5v0__fillcap_32_0/a_36_472# 0.03404f
C713 count[1] gf180mcu_fd_sc_mcu7t5v0__dffq_1_3/a_2011_527# 0
C714 gf180mcu_fd_sc_mcu7t5v0__xnor2_1_1/A2 gf180mcu_fd_sc_mcu7t5v0__dffq_1_3/a_448_472# 0
C715 gf180mcu_fd_sc_mcu7t5v0__dffq_1_1/D gf180mcu_fd_sc_mcu7t5v0__dffq_1_1/a_1328_159# 0.00129f
C716 gf180mcu_fd_sc_mcu7t5v0__fillcap_32_3/a_36_472# gf180mcu_fd_sc_mcu7t5v0__fillcap_16_2/a_1380_472# 0.00276f
C717 VDD gf180mcu_fd_sc_mcu7t5v0__dffq_1_2/a_1004_159# 0.00445f
C718 gf180mcu_fd_sc_mcu7t5v0__dlyb_1_3/a_895_68# gf180mcu_fd_sc_mcu7t5v0__dlyb_1_2/I 0.00458f
C719 gf180mcu_fd_sc_mcu7t5v0__fillcap_4_0/a_36_472# gf180mcu_fd_sc_mcu7t5v0__clkbuf_16_2/Z 0
C720 gf180mcu_fd_sc_mcu7t5v0__dffq_1_3/a_2011_527# gf180mcu_fd_sc_mcu7t5v0__fillcap_4_12/a_36_472# 0
C721 gf180mcu_fd_sc_mcu7t5v0__fillcap_32_3/a_2724_472# gf180mcu_fd_sc_mcu7t5v0__fillcap_32_0/a_2812_375# 0.00154f
C722 VDD gf180mcu_fd_sc_mcu7t5v0__fillcap_32_0/a_2812_375# 0.02336f
C723 clk gf180mcu_fd_sc_mcu7t5v0__fillcap_32_5/a_2364_375# 0.00116f
C724 gf180mcu_fd_sc_mcu7t5v0__dlyb_1_1/I gf180mcu_fd_sc_mcu7t5v0__dffq_1_1/a_2011_527# 0.01404f
C725 gf180mcu_fd_sc_mcu7t5v0__fillcap_32_3/a_36_472# gf180mcu_fd_sc_mcu7t5v0__clkbuf_16_2/a_224_552# 0.001f
C726 gf180mcu_fd_sc_mcu7t5v0__fillcap_32_1/a_3172_472# gf180mcu_fd_sc_mcu7t5v0__fillcap_4_0/a_36_472# 0.01328f
C727 gf180mcu_fd_sc_mcu7t5v0__dffq_1_3/CLK gf180mcu_fd_sc_mcu7t5v0__fillcap_32_0/a_484_472# 0.00152f
C728 gf180mcu_fd_sc_mcu7t5v0__dffq_1_0/a_1376_115# gf180mcu_fd_sc_mcu7t5v0__xnor2_1_0/A2 0.02075f
C729 gf180mcu_fd_sc_mcu7t5v0__dlyb_1_3/a_1147_68# gf180mcu_fd_sc_mcu7t5v0__xnor2_1_0/A2 0
C730 gf180mcu_fd_sc_mcu7t5v0__dffq_1_0/a_448_472# gf180mcu_fd_sc_mcu7t5v0__dffq_1_2/a_2011_527# 0
C731 gf180mcu_fd_sc_mcu7t5v0__dffq_1_0/a_36_151# gf180mcu_fd_sc_mcu7t5v0__dffq_1_2/a_2304_115# 0.00617f
C732 gf180mcu_fd_sc_mcu7t5v0__dffq_1_2/a_36_151# gf180mcu_fd_sc_mcu7t5v0__fillcap_16_0/a_36_472# 0.08647f
C733 gf180mcu_fd_sc_mcu7t5v0__xnor2_1_1/A2 gf180mcu_fd_sc_mcu7t5v0__dffq_1_0/a_836_159# 0
C734 gf180mcu_fd_sc_mcu7t5v0__fillcap_32_0/a_484_472# gf180mcu_fd_sc_mcu7t5v0__fillcap_32_1/a_124_375# 0.00168f
C735 gf180mcu_fd_sc_mcu7t5v0__dffq_1_2/D gf180mcu_fd_sc_mcu7t5v0__dffq_1_2/a_1004_159# 0.02097f
C736 gf180mcu_fd_sc_mcu7t5v0__dlyb_1_3/a_895_68# gf180mcu_fd_sc_mcu7t5v0__dlyb_1_1/I 0.00241f
C737 gf180mcu_fd_sc_mcu7t5v0__dlyb_1_0/a_1127_622# gf180mcu_fd_sc_mcu7t5v0__dlyb_1_1/I 0.00125f
C738 gf180mcu_fd_sc_mcu7t5v0__dlyb_1_0/I gf180mcu_fd_sc_mcu7t5v0__xnor2_1_1/A2 0.04754f
C739 VDD gf180mcu_fd_sc_mcu7t5v0__fillcap_32_5/a_1380_472# 0
C740 VDD gf180mcu_fd_sc_mcu7t5v0__xnor2_1_1/A2 0.14853f
C741 gf180mcu_fd_sc_mcu7t5v0__fillcap_32_0/a_3260_375# gf180mcu_fd_sc_mcu7t5v0__clkbuf_16_2/Z 0.0058f
C742 gf180mcu_fd_sc_mcu7t5v0__dffq_1_2/a_2011_527# gf180mcu_fd_sc_mcu7t5v0__clkbuf_16_2/Z 0
C743 gf180mcu_fd_sc_mcu7t5v0__dlyb_1_2/I gf180mcu_fd_sc_mcu7t5v0__xnor2_1_0/a_272_93# 0.00137f
C744 gf180mcu_fd_sc_mcu7t5v0__xor2_1_0/Z gf180mcu_fd_sc_mcu7t5v0__dffq_1_3/a_1004_159# 0.04288f
C745 gf180mcu_fd_sc_mcu7t5v0__fillcap_32_1/a_3172_472# gf180mcu_fd_sc_mcu7t5v0__fillcap_32_0/a_3260_375# 0.00168f
C746 gf180mcu_fd_sc_mcu7t5v0__fillcap_16_2/a_1020_375# gf180mcu_fd_sc_mcu7t5v0__clkbuf_16_2/a_224_552# 0.03233f
C747 gf180mcu_fd_sc_mcu7t5v0__fillcap_32_2/a_1380_472# gf180mcu_fd_sc_mcu7t5v0__clkbuf_16_1/a_224_552# 0
C748 gf180mcu_fd_sc_mcu7t5v0__dlyb_1_3/I gf180mcu_fd_sc_mcu7t5v0__fillcap_32_5/a_36_472# 0
C749 gf180mcu_fd_sc_mcu7t5v0__dlyb_1_0/I gf180mcu_fd_sc_mcu7t5v0__fillcap_4_4/a_124_375# 0.00972f
C750 gf180mcu_fd_sc_mcu7t5v0__xnor2_1_1/A2 gf180mcu_fd_sc_mcu7t5v0__dffq_1_2/D 0.04163f
C751 gf180mcu_fd_sc_mcu7t5v0__dffq_1_2/D gf180mcu_fd_sc_mcu7t5v0__fillcap_32_5/a_1380_472# 0.00118f
C752 VDD gf180mcu_fd_sc_mcu7t5v0__fillcap_4_4/a_124_375# 0.01093f
C753 gf180mcu_fd_sc_mcu7t5v0__dffq_1_2/CLK gf180mcu_fd_sc_mcu7t5v0__dffq_1_0/a_36_151# 0.0319f
C754 gf180mcu_fd_sc_mcu7t5v0__dffq_1_2/CLK gf180mcu_fd_sc_mcu7t5v0__dlyb_1_2/I 0
C755 gf180mcu_fd_sc_mcu7t5v0__clkbuf_16_1/a_224_552# gf180mcu_fd_sc_mcu7t5v0__fillcap_32_2/a_572_375# 0.03233f
C756 gf180mcu_fd_sc_mcu7t5v0__fillcap_32_5/a_1828_472# gf180mcu_fd_sc_mcu7t5v0__clkbuf_16_2/Z 0.05229f
C757 gf180mcu_fd_sc_mcu7t5v0__clkbuf_16_1/a_224_552# gf180mcu_fd_sc_mcu7t5v0__dffq_1_1/a_36_151# 0.01717f
C758 gf180mcu_fd_sc_mcu7t5v0__dffq_1_2/a_448_472# gf180mcu_fd_sc_mcu7t5v0__fillcap_32_5/a_484_472# 0.00116f
C759 gf180mcu_fd_sc_mcu7t5v0__dffq_1_0/a_1376_115# gf180mcu_fd_sc_mcu7t5v0__dlyb_1_3/I 0.00933f
C760 gf180mcu_fd_sc_mcu7t5v0__dlyb_1_3/a_1147_68# gf180mcu_fd_sc_mcu7t5v0__dlyb_1_3/I 0
C761 gf180mcu_fd_sc_mcu7t5v0__fillcap_8_1/a_572_375# gf180mcu_fd_sc_mcu7t5v0__clkbuf_16_2/a_224_552# 0
C762 gf180mcu_fd_sc_mcu7t5v0__fillcap_32_2/a_3172_472# gf180mcu_fd_sc_mcu7t5v0__fillcap_32_2/a_3260_375# 0
C763 gf180mcu_fd_sc_mcu7t5v0__xor2_1_0/Z gf180mcu_fd_sc_mcu7t5v0__dffq_1_1/a_2011_527# 0.03355f
C764 gf180mcu_fd_sc_mcu7t5v0__xnor2_1_1/a_930_497# gf180mcu_fd_sc_mcu7t5v0__dlyb_1_3/I 0.00153f
C765 gf180mcu_fd_sc_mcu7t5v0__dlyb_1_0/I gf180mcu_fd_sc_mcu7t5v0__dffq_1_3/a_1004_159# 0.00296f
C766 gf180mcu_fd_sc_mcu7t5v0__fillcap_32_0/a_2276_472# gf180mcu_fd_sc_mcu7t5v0__fillcap_32_3/a_1828_472# 0
C767 gf180mcu_fd_sc_mcu7t5v0__dffq_1_2/a_36_151# gf180mcu_fd_sc_mcu7t5v0__fillcap_32_4/a_572_375# 0
C768 gf180mcu_fd_sc_mcu7t5v0__fillcap_16_1/a_572_375# gf180mcu_fd_sc_mcu7t5v0__dlyb_1_2/I 0
C769 VDD gf180mcu_fd_sc_mcu7t5v0__fillcap_32_5/a_2724_472# -0
C770 VDD gf180mcu_fd_sc_mcu7t5v0__dffq_1_3/a_1004_159# 0.01509f
C771 gf180mcu_fd_sc_mcu7t5v0__clkbuf_16_1/a_224_552# gf180mcu_fd_sc_mcu7t5v0__fillcap_8_0/a_124_375# 0.03233f
C772 VDD gf180mcu_fd_sc_mcu7t5v0__fillcap_4_8/a_124_375# 0.04411f
C773 VDD gf180mcu_fd_sc_mcu7t5v0__fillcap_16_1/a_484_472# 0.00644f
C774 gf180mcu_fd_sc_mcu7t5v0__dffq_1_1/a_2011_527# gf180mcu_fd_sc_mcu7t5v0__dffq_1_3/a_448_472# 0
C775 gf180mcu_fd_sc_mcu7t5v0__xor2_1_0/Z gf180mcu_fd_sc_mcu7t5v0__dffq_1_1/a_1328_159# 0
C776 gf180mcu_fd_sc_mcu7t5v0__fillcap_32_5/a_1468_375# gf180mcu_fd_sc_mcu7t5v0__fillcap_16_0/a_124_375# 0.05841f
C777 gf180mcu_fd_sc_mcu7t5v0__xnor2_1_1/a_716_68# gf180mcu_fd_sc_mcu7t5v0__dffq_1_2/a_36_151# 0
C778 gf180mcu_fd_sc_mcu7t5v0__fillcap_32_3/a_1380_472# gf180mcu_fd_sc_mcu7t5v0__clkbuf_16_2/a_224_552# 0.001f
C779 VDD gf180mcu_fd_sc_mcu7t5v0__fillcap_32_1/a_932_472# 0.00336f
C780 gf180mcu_fd_sc_mcu7t5v0__dlyb_1_2/I gf180mcu_fd_sc_mcu7t5v0__fillcap_16_1/a_1380_472# 0
C781 gf180mcu_fd_sc_mcu7t5v0__clkbuf_16_0/a_224_552# gf180mcu_fd_sc_mcu7t5v0__fillcap_32_4/a_1020_375# 0.02641f
C782 gf180mcu_fd_sc_mcu7t5v0__xor2_1_0/Z gf180mcu_fd_sc_mcu7t5v0__fillcap_32_0/a_36_472# 0
C783 gf180mcu_fd_sc_mcu7t5v0__fillcap_32_5/a_3172_472# gf180mcu_fd_sc_mcu7t5v0__clkbuf_16_2/Z 0.00247f
C784 gf180mcu_fd_sc_mcu7t5v0__fillcap_32_4/a_1916_375# gf180mcu_fd_sc_mcu7t5v0__clkbuf_16_2/Z 0.08652f
C785 gf180mcu_fd_sc_mcu7t5v0__dffq_1_3/CLK gf180mcu_fd_sc_mcu7t5v0__fillcap_4_13/a_124_375# 0.00396f
C786 VDD gf180mcu_fd_sc_mcu7t5v0__fillcap_32_2/a_2364_375# 0.00122f
C787 gf180mcu_fd_sc_mcu7t5v0__dffq_1_3/CLK gf180mcu_fd_sc_mcu7t5v0__dffq_1_1/a_880_527# 0
C788 gf180mcu_fd_sc_mcu7t5v0__dlyb_1_0/a_895_68# gf180mcu_fd_sc_mcu7t5v0__fillcap_8_1/a_124_375# 0.02977f
C789 gf180mcu_fd_sc_mcu7t5v0__fillcap_32_0/a_2276_472# gf180mcu_fd_sc_mcu7t5v0__fillcap_32_1/a_1916_375# 0.00168f
C790 VDD gf180mcu_fd_sc_mcu7t5v0__fillcap_32_4/a_124_375# 0.01563f
C791 gf180mcu_fd_sc_mcu7t5v0__dlyb_1_0/I gf180mcu_fd_sc_mcu7t5v0__dffq_1_1/a_2011_527# 0.0282f
C792 gf180mcu_fd_sc_mcu7t5v0__dffq_1_3/a_448_472# gf180mcu_fd_sc_mcu7t5v0__fillcap_32_0/a_36_472# 0
C793 gf180mcu_fd_sc_mcu7t5v0__fillcap_32_3/a_124_375# gf180mcu_fd_sc_mcu7t5v0__fillcap_16_2/a_1468_375# 0.00443f
C794 VDD gf180mcu_fd_sc_mcu7t5v0__dffq_1_1/a_2011_527# 0.01924f
C795 gf180mcu_fd_sc_mcu7t5v0__fillcap_16_0/a_932_472# gf180mcu_fd_sc_mcu7t5v0__fillcap_32_4/a_2276_472# 0.05841f
C796 gf180mcu_fd_sc_mcu7t5v0__xor2_1_0/Z gf180mcu_fd_sc_mcu7t5v0__fillcap_32_0/a_484_472# 0
C797 count[1] gf180mcu_fd_sc_mcu7t5v0__fillcap_4_6/a_124_375# 0
C798 clk gf180mcu_fd_sc_mcu7t5v0__fillcap_32_0/a_1916_375# 0
C799 gf180mcu_fd_sc_mcu7t5v0__dffq_1_1/D gf180mcu_fd_sc_mcu7t5v0__fillcap_16_2/a_36_472# 0
C800 gf180mcu_fd_sc_mcu7t5v0__fillcap_4_7/a_124_375# gf180mcu_fd_sc_mcu7t5v0__fillcap_4_6/a_124_375# 0
C801 gf180mcu_fd_sc_mcu7t5v0__dffq_1_1/D gf180mcu_fd_sc_mcu7t5v0__fillcap_4_13/a_124_375# 0
C802 gf180mcu_fd_sc_mcu7t5v0__dffq_1_1/D gf180mcu_fd_sc_mcu7t5v0__dffq_1_1/a_880_527# 0
C803 gf180mcu_fd_sc_mcu7t5v0__dffq_1_2/D gf180mcu_fd_sc_mcu7t5v0__fillcap_32_4/a_124_375# 0.00398f
C804 VDD gf180mcu_fd_sc_mcu7t5v0__xnor2_1_0/a_930_497# 0
C805 gf180mcu_fd_sc_mcu7t5v0__fillcap_32_2/a_2812_375# gf180mcu_fd_sc_mcu7t5v0__clkbuf_16_2/Z 0.03241f
C806 gf180mcu_fd_sc_mcu7t5v0__dlyb_1_0/a_1127_622# gf180mcu_fd_sc_mcu7t5v0__dlyb_1_0/I 0
C807 VDD gf180mcu_fd_sc_mcu7t5v0__dlyb_1_3/a_895_68# 0.0028f
C808 gf180mcu_fd_sc_mcu7t5v0__dffq_1_2/CLK gf180mcu_fd_sc_mcu7t5v0__dffq_1_2/a_1328_159# 0
C809 gf180mcu_fd_sc_mcu7t5v0__fillcap_32_0/a_484_472# gf180mcu_fd_sc_mcu7t5v0__dffq_1_3/a_448_472# 0
C810 VDD gf180mcu_fd_sc_mcu7t5v0__dlyb_1_0/a_1127_622# 0
C811 VDD gf180mcu_fd_sc_mcu7t5v0__dffq_1_1/a_1328_159# 0
C812 gf180mcu_fd_sc_mcu7t5v0__xor2_1_0/a_56_604# gf180mcu_fd_sc_mcu7t5v0__dffq_1_3/a_2304_115# 0
C813 gf180mcu_fd_sc_mcu7t5v0__fillcap_16_2/a_1468_375# gf180mcu_fd_sc_mcu7t5v0__clkbuf_16_2/Z 0.00167f
C814 gf180mcu_fd_sc_mcu7t5v0__dlyb_1_3/a_671_644# gf180mcu_fd_sc_mcu7t5v0__dffq_1_0/a_2304_115# 0.00282f
C815 gf180mcu_fd_sc_mcu7t5v0__dlyb_1_3/a_895_68# gf180mcu_fd_sc_mcu7t5v0__dffq_1_0/a_2011_527# 0
C816 gf180mcu_fd_sc_mcu7t5v0__xnor2_1_1/A2 gf180mcu_fd_sc_mcu7t5v0__dffq_1_3/a_1004_159# 0
C817 gf180mcu_fd_sc_mcu7t5v0__clkbuf_16_2/Z gf180mcu_fd_sc_mcu7t5v0__fillcap_32_5/a_3260_375# 0.00258f
C818 gf180mcu_fd_sc_mcu7t5v0__fillcap_4_3/a_124_375# gf180mcu_fd_sc_mcu7t5v0__fillcap_4_4/a_36_472# 0.0027f
C819 gf180mcu_fd_sc_mcu7t5v0__fillcap_16_2/a_124_375# gf180mcu_fd_sc_mcu7t5v0__clkbuf_16_2/a_224_552# 0
C820 gf180mcu_fd_sc_mcu7t5v0__dlyb_1_3/a_1147_68# gf180mcu_fd_sc_mcu7t5v0__dlyb_1_2/I 0
C821 gf180mcu_fd_sc_mcu7t5v0__dlyb_1_1/I gf180mcu_fd_sc_mcu7t5v0__fillcap_16_2/a_36_472# 0.00149f
C822 gf180mcu_fd_sc_mcu7t5v0__dlyb_1_0/a_47_68# gf180mcu_fd_sc_mcu7t5v0__xnor2_1_0/A2 0
C823 VDD gf180mcu_fd_sc_mcu7t5v0__dffq_1_2/a_2304_115# 0.03688f
C824 VDD gf180mcu_fd_sc_mcu7t5v0__fillcap_32_0/a_36_472# 0.01918f
C825 gf180mcu_fd_sc_mcu7t5v0__fillcap_32_3/a_3172_472# gf180mcu_fd_sc_mcu7t5v0__fillcap_32_0/a_3260_375# 0.00154f
C826 gf180mcu_fd_sc_mcu7t5v0__clkbuf_16_0/a_224_552# gf180mcu_fd_sc_mcu7t5v0__fillcap_32_6/a_1828_472# 0
C827 gf180mcu_fd_sc_mcu7t5v0__dlyb_1_1/I gf180mcu_fd_sc_mcu7t5v0__fillcap_4_13/a_124_375# 0
C828 gf180mcu_fd_sc_mcu7t5v0__dffq_1_3/CLK gf180mcu_fd_sc_mcu7t5v0__fillcap_32_0/a_1380_472# 0
C829 gf180mcu_fd_sc_mcu7t5v0__dffq_1_2/a_448_472# gf180mcu_fd_sc_mcu7t5v0__fillcap_16_0/a_484_472# 0
C830 gf180mcu_fd_sc_mcu7t5v0__nand3_1_0/a_271_68# gf180mcu_fd_sc_mcu7t5v0__xnor2_1_0/A2 0
C831 gf180mcu_fd_sc_mcu7t5v0__fillcap_4_4/a_36_472# count[0] 0.00423f
C832 gf180mcu_fd_sc_mcu7t5v0__fillcap_32_0/a_932_472# gf180mcu_fd_sc_mcu7t5v0__fillcap_32_1/a_572_375# 0.00168f
C833 gf180mcu_fd_sc_mcu7t5v0__dlyb_1_3/a_1147_68# gf180mcu_fd_sc_mcu7t5v0__dlyb_1_1/I 0
C834 gf180mcu_fd_sc_mcu7t5v0__dffq_1_2/D gf180mcu_fd_sc_mcu7t5v0__dffq_1_2/a_2304_115# 0
C835 VDD gf180mcu_fd_sc_mcu7t5v0__fillcap_32_0/a_484_472# 0.01124f
C836 gf180mcu_fd_sc_mcu7t5v0__fillcap_32_3/a_572_375# gf180mcu_fd_sc_mcu7t5v0__clkbuf_16_2/Z 0.00451f
C837 gf180mcu_fd_sc_mcu7t5v0__dffq_1_2/a_880_527# gf180mcu_fd_sc_mcu7t5v0__clkbuf_16_2/Z 0
C838 gf180mcu_fd_sc_mcu7t5v0__fillcap_4_3/a_124_375# gf180mcu_fd_sc_mcu7t5v0__dffq_1_3/a_2011_527# 0
C839 gf180mcu_fd_sc_mcu7t5v0__fillcap_32_1/a_2364_375# gf180mcu_fd_sc_mcu7t5v0__fillcap_32_0/a_2364_375# 0
C840 VDD gf180mcu_fd_sc_mcu7t5v0__fillcap_4_8/a_36_472# 0.09454f
C841 VDD gf180mcu_fd_sc_mcu7t5v0__dffq_1_2/CLK 0.50188f
C842 gf180mcu_fd_sc_mcu7t5v0__fillcap_4_7/a_36_472# gf180mcu_fd_sc_mcu7t5v0__fillcap_16_2/a_36_472# 0
C843 VDD gf180mcu_fd_sc_mcu7t5v0__fillcap_4_1/a_124_375# 0.04864f
C844 gf180mcu_fd_sc_mcu7t5v0__dlyb_1_0/a_47_68# gf180mcu_fd_sc_mcu7t5v0__fillcap_4_12/a_124_375# 0.0296f
C845 gf180mcu_fd_sc_mcu7t5v0__fillcap_32_0/a_932_472# gf180mcu_fd_sc_mcu7t5v0__clkbuf_16_2/Z 0.00268f
C846 gf180mcu_fd_sc_mcu7t5v0__dffq_1_2/a_448_472# gf180mcu_fd_sc_mcu7t5v0__clkbuf_16_2/a_224_552# 0.00239f
C847 gf180mcu_fd_sc_mcu7t5v0__fillcap_32_5/a_1020_375# gf180mcu_fd_sc_mcu7t5v0__clkbuf_16_2/a_224_552# 0.00118f
C848 gf180mcu_fd_sc_mcu7t5v0__clkbuf_16_1/a_224_552# gf180mcu_fd_sc_mcu7t5v0__fillcap_32_2/a_1468_375# 0.03233f
C849 gf180mcu_fd_sc_mcu7t5v0__dffq_1_2/D gf180mcu_fd_sc_mcu7t5v0__dffq_1_2/CLK 0.0073f
C850 gf180mcu_fd_sc_mcu7t5v0__clkbuf_16_1/a_224_552# gf180mcu_fd_sc_mcu7t5v0__dffq_1_1/a_1376_115# 0.00137f
C851 gf180mcu_fd_sc_mcu7t5v0__fillcap_32_6/a_2724_472# gf180mcu_fd_sc_mcu7t5v0__clkbuf_16_2/Z 0.01557f
C852 VDD gf180mcu_fd_sc_mcu7t5v0__fillcap_16_1/a_572_375# 0.00815f
C853 gf180mcu_fd_sc_mcu7t5v0__xnor2_1_1/A2 gf180mcu_fd_sc_mcu7t5v0__dffq_1_2/a_2304_115# 0.01011f
C854 gf180mcu_fd_sc_mcu7t5v0__xor2_1_0/Z gf180mcu_fd_sc_mcu7t5v0__fillcap_16_2/a_36_472# 0.00559f
C855 gf180mcu_fd_sc_mcu7t5v0__xor2_1_0/Z gf180mcu_fd_sc_mcu7t5v0__dffq_1_1/a_880_527# 0
C856 gf180mcu_fd_sc_mcu7t5v0__dffq_1_2/CLK gf180mcu_fd_sc_mcu7t5v0__dffq_1_2/a_1004_159# 0.00489f
C857 clk gf180mcu_fd_sc_mcu7t5v0__fillcap_32_3/a_2276_472# 0
C858 VDD gf180mcu_fd_sc_mcu7t5v0__fillcap_32_4/a_2364_375# 0.00198f
C859 gf180mcu_fd_sc_mcu7t5v0__clkbuf_16_1/a_224_552# gf180mcu_fd_sc_mcu7t5v0__fillcap_8_0/a_36_472# 0
C860 gf180mcu_fd_sc_mcu7t5v0__fillcap_16_2/a_36_472# gf180mcu_fd_sc_mcu7t5v0__dffq_1_3/a_448_472# 0
C861 gf180mcu_fd_sc_mcu7t5v0__fillcap_16_2/a_484_472# gf180mcu_fd_sc_mcu7t5v0__dffq_1_3/a_36_151# 0
C862 gf180mcu_fd_sc_mcu7t5v0__dlyb_1_0/a_895_68# gf180mcu_fd_sc_mcu7t5v0__dffq_1_1/a_2304_115# 0
C863 VDD gf180mcu_fd_sc_mcu7t5v0__fillcap_16_1/a_1380_472# 0.01873f
C864 gf180mcu_fd_sc_mcu7t5v0__dlyb_1_0/a_671_644# gf180mcu_fd_sc_mcu7t5v0__fillcap_4_12/a_124_375# 0
C865 gf180mcu_fd_sc_mcu7t5v0__fillcap_16_0/a_1468_375# gf180mcu_fd_sc_mcu7t5v0__fillcap_4_9/a_36_472# 0.08663f
C866 gf180mcu_fd_sc_mcu7t5v0__dlyb_1_0/a_671_644# gf180mcu_fd_sc_mcu7t5v0__dlyb_1_3/I 0
C867 clk gf180mcu_fd_sc_mcu7t5v0__fillcap_4_9/a_36_472# 0
C868 gf180mcu_fd_sc_mcu7t5v0__dffq_1_0/a_2256_159# gf180mcu_fd_sc_mcu7t5v0__xnor2_1_0/A2 0
C869 gf180mcu_fd_sc_mcu7t5v0__xnor2_1_1/A2 gf180mcu_fd_sc_mcu7t5v0__dffq_1_2/CLK 0
C870 gf180mcu_fd_sc_mcu7t5v0__fillcap_16_0/a_1468_375# gf180mcu_fd_sc_mcu7t5v0__clkbuf_16_2/Z 0.00535f
C871 gf180mcu_fd_sc_mcu7t5v0__clkbuf_16_0/a_224_552# gf180mcu_fd_sc_mcu7t5v0__fillcap_32_4/a_36_472# 0.001f
C872 clk gf180mcu_fd_sc_mcu7t5v0__clkbuf_16_2/Z 0.086f
C873 gf180mcu_fd_sc_mcu7t5v0__clkbuf_16_0/a_224_552# gf180mcu_fd_sc_mcu7t5v0__dffq_1_2/a_36_151# 0.00449f
C874 gf180mcu_fd_sc_mcu7t5v0__fillcap_32_4/a_2812_375# gf180mcu_fd_sc_mcu7t5v0__clkbuf_16_2/Z 0.03485f
C875 gf180mcu_fd_sc_mcu7t5v0__fillcap_16_2/a_36_472# gf180mcu_fd_sc_mcu7t5v0__dlyb_1_0/a_503_644# 0
C876 gf180mcu_fd_sc_mcu7t5v0__fillcap_32_0/a_1828_472# gf180mcu_fd_sc_mcu7t5v0__clkbuf_16_2/Z 0.01663f
C877 gf180mcu_fd_sc_mcu7t5v0__clkbuf_16_1/a_224_552# gf180mcu_fd_sc_mcu7t5v0__fillcap_32_2/a_36_472# 0
C878 gf180mcu_fd_sc_mcu7t5v0__dlyb_1_0/I gf180mcu_fd_sc_mcu7t5v0__fillcap_16_2/a_36_472# 0.01884f
C879 VDD gf180mcu_fd_sc_mcu7t5v0__fillcap_16_2/a_36_472# 0.02365f
C880 gf180mcu_fd_sc_mcu7t5v0__dffq_1_3/CLK gf180mcu_fd_sc_mcu7t5v0__fillcap_32_2/a_572_375# 0.00121f
C881 VDD gf180mcu_fd_sc_mcu7t5v0__fillcap_32_5/a_36_472# 0.10633f
C882 VDD gf180mcu_fd_sc_mcu7t5v0__fillcap_4_13/a_124_375# 0.04285f
C883 gf180mcu_fd_sc_mcu7t5v0__fillcap_16_0/a_1380_472# gf180mcu_fd_sc_mcu7t5v0__fillcap_32_4/a_2724_472# 0.05841f
C884 gf180mcu_fd_sc_mcu7t5v0__dffq_1_3/CLK gf180mcu_fd_sc_mcu7t5v0__dffq_1_1/a_36_151# 0.08143f
C885 VDD gf180mcu_fd_sc_mcu7t5v0__dffq_1_1/a_880_527# 0
C886 gf180mcu_fd_sc_mcu7t5v0__clkbuf_16_0/a_224_552# gf180mcu_fd_sc_mcu7t5v0__fillcap_32_6/a_484_472# 0.01591f
C887 gf180mcu_fd_sc_mcu7t5v0__dffq_1_1/a_36_151# gf180mcu_fd_sc_mcu7t5v0__fillcap_32_1/a_124_375# 0.00156f
C888 VDD gf180mcu_fd_sc_mcu7t5v0__dffq_1_0/a_1376_115# 0.00682f
C889 gf180mcu_fd_sc_mcu7t5v0__dffq_1_2/D gf180mcu_fd_sc_mcu7t5v0__fillcap_32_5/a_36_472# 0.0296f
C890 VDD gf180mcu_fd_sc_mcu7t5v0__fillcap_32_4/a_932_472# 0.00195f
C891 VDD gf180mcu_fd_sc_mcu7t5v0__fillcap_32_1/a_2364_375# 0.02153f
C892 gf180mcu_fd_sc_mcu7t5v0__dffq_1_0/a_2256_159# gf180mcu_fd_sc_mcu7t5v0__dlyb_1_3/I 0
C893 gf180mcu_fd_sc_mcu7t5v0__dffq_1_1/D gf180mcu_fd_sc_mcu7t5v0__dffq_1_1/a_36_151# 0.0113f
C894 gf180mcu_fd_sc_mcu7t5v0__clkbuf_16_2/Z gf180mcu_fd_sc_mcu7t5v0__fillcap_32_5/a_484_472# 0.00311f
C895 gf180mcu_fd_sc_mcu7t5v0__dffq_1_3/CLK gf180mcu_fd_sc_mcu7t5v0__fillcap_8_0/a_124_375# 0.00167f
C896 VDD gf180mcu_fd_sc_mcu7t5v0__fillcap_32_3/a_1020_375# 0.01518f
C897 VDD gf180mcu_fd_sc_mcu7t5v0__xnor2_1_1/a_930_497# 0.01781f
C898 VDD gf180mcu_fd_sc_mcu7t5v0__fillcap_16_0/a_124_375# -0.00814f
C899 gf180mcu_fd_sc_mcu7t5v0__clkbuf_16_0/a_224_552# gf180mcu_fd_sc_mcu7t5v0__dffq_1_0/D 0.04723f
C900 gf180mcu_fd_sc_mcu7t5v0__dffq_1_1/a_448_472# gf180mcu_fd_sc_mcu7t5v0__dffq_1_3/a_2304_115# 0.0036f
C901 VDD gf180mcu_fd_sc_mcu7t5v0__fillcap_32_6/a_1020_375# 0
C902 gf180mcu_fd_sc_mcu7t5v0__clkbuf_16_1/a_224_552# gf180mcu_fd_sc_mcu7t5v0__fillcap_32_1/a_1468_375# 0.00118f
C903 gf180mcu_fd_sc_mcu7t5v0__dlyb_1_0/a_47_68# gf180mcu_fd_sc_mcu7t5v0__dlyb_1_1/I 0.02035f
C904 gf180mcu_fd_sc_mcu7t5v0__dffq_1_2/CLK gf180mcu_fd_sc_mcu7t5v0__fillcap_16_1/a_484_472# 0
C905 gf180mcu_fd_sc_mcu7t5v0__fillcap_32_0/a_124_375# gf180mcu_fd_sc_mcu7t5v0__clkbuf_16_2/a_224_552# 0
C906 gf180mcu_fd_sc_mcu7t5v0__fillcap_32_1/a_2812_375# gf180mcu_fd_sc_mcu7t5v0__clkbuf_16_2/Z 0.00636f
C907 gf180mcu_fd_sc_mcu7t5v0__dffq_1_0/a_36_151# gf180mcu_fd_sc_mcu7t5v0__xnor2_1_1/a_716_68# 0
C908 gf180mcu_fd_sc_mcu7t5v0__fillcap_32_4/a_1380_472# gf180mcu_fd_sc_mcu7t5v0__clkbuf_16_2/Z 0.00857f
C909 gf180mcu_fd_sc_mcu7t5v0__dlyb_1_1/I gf180mcu_fd_sc_mcu7t5v0__dffq_1_1/a_36_151# 0.00773f
C910 gf180mcu_fd_sc_mcu7t5v0__dffq_1_2/D gf180mcu_fd_sc_mcu7t5v0__fillcap_16_0/a_124_375# 0.00196f
C911 gf180mcu_fd_sc_mcu7t5v0__dffq_1_1/D gf180mcu_fd_sc_mcu7t5v0__fillcap_8_0/a_124_375# 0.01145f
C912 gf180mcu_fd_sc_mcu7t5v0__fillcap_16_2/a_932_472# gf180mcu_fd_sc_mcu7t5v0__clkbuf_16_2/a_224_552# 0
C913 gf180mcu_fd_sc_mcu7t5v0__dffq_1_2/D gf180mcu_fd_sc_mcu7t5v0__xnor2_1_1/a_930_497# 0.00269f
C914 VDD gf180mcu_fd_sc_mcu7t5v0__fillcap_32_0/a_1380_472# 0.01124f
C915 gf180mcu_fd_sc_mcu7t5v0__nand3_1_0/a_271_68# gf180mcu_fd_sc_mcu7t5v0__dlyb_1_1/I 0.00273f
C916 gf180mcu_fd_sc_mcu7t5v0__fillcap_32_3/a_1468_375# gf180mcu_fd_sc_mcu7t5v0__clkbuf_16_2/Z 0.02076f
C917 gf180mcu_fd_sc_mcu7t5v0__fillcap_16_0/a_572_375# gf180mcu_fd_sc_mcu7t5v0__clkbuf_16_2/Z 0.05654f
C918 gf180mcu_fd_sc_mcu7t5v0__fillcap_32_1/a_2364_375# gf180mcu_fd_sc_mcu7t5v0__fillcap_32_0/a_2812_375# 0
C919 VDD gf180mcu_fd_sc_mcu7t5v0__fillcap_32_5/a_124_375# 0.02552f
C920 gf180mcu_fd_sc_mcu7t5v0__fillcap_4_11/a_36_472# gf180mcu_fd_sc_mcu7t5v0__fillcap_4_10/a_124_375# 0.00144f
C921 gf180mcu_fd_sc_mcu7t5v0__xnor2_1_1/A2 gf180mcu_fd_sc_mcu7t5v0__fillcap_16_2/a_36_472# 0.00145f
C922 VDD gf180mcu_fd_sc_mcu7t5v0__fillcap_32_6/a_3172_472# 0.00582f
C923 gf180mcu_fd_sc_mcu7t5v0__xnor2_1_1/A2 gf180mcu_fd_sc_mcu7t5v0__fillcap_32_5/a_36_472# 0.00285f
C924 gf180mcu_fd_sc_mcu7t5v0__dffq_1_2/CLK gf180mcu_fd_sc_mcu7t5v0__fillcap_32_4/a_124_375# 0.01661f
C925 gf180mcu_fd_sc_mcu7t5v0__dlyb_1_0/a_47_68# gf180mcu_fd_sc_mcu7t5v0__fillcap_4_7/a_36_472# 0
C926 gf180mcu_fd_sc_mcu7t5v0__dlyb_1_1/I gf180mcu_fd_sc_mcu7t5v0__fillcap_8_0/a_124_375# 0.00897f
C927 gf180mcu_fd_sc_mcu7t5v0__dffq_1_3/CLK gf180mcu_fd_sc_mcu7t5v0__dffq_1_3/a_1348_527# 0
C928 gf180mcu_fd_sc_mcu7t5v0__clkbuf_16_0/a_224_552# gf180mcu_fd_sc_mcu7t5v0__xnor2_1_0/A2 0.00728f
C929 gf180mcu_fd_sc_mcu7t5v0__dlyb_1_1/a_1127_622# gf180mcu_fd_sc_mcu7t5v0__dlyb_1_1/I 0
C930 gf180mcu_fd_sc_mcu7t5v0__dffq_1_1/a_448_472# gf180mcu_fd_sc_mcu7t5v0__fillcap_16_2/a_932_472# 0
C931 gf180mcu_fd_sc_mcu7t5v0__dffq_1_2/D gf180mcu_fd_sc_mcu7t5v0__fillcap_32_5/a_124_375# 0.0387f
C932 clk gf180mcu_fd_sc_mcu7t5v0__fillcap_32_5/a_2276_472# 0.0136f
C933 gf180mcu_fd_sc_mcu7t5v0__dffq_1_1/a_36_151# gf180mcu_fd_sc_mcu7t5v0__xor2_1_0/a_728_472# 0
C934 gf180mcu_fd_sc_mcu7t5v0__dlyb_1_0/a_671_644# gf180mcu_fd_sc_mcu7t5v0__dlyb_1_1/I 0.05003f
C935 gf180mcu_fd_sc_mcu7t5v0__fillcap_32_2/a_124_375# gf180mcu_fd_sc_mcu7t5v0__clkbuf_16_1/a_224_552# 0.03232f
C936 VDD gf180mcu_fd_sc_mcu7t5v0__fillcap_32_6/a_2364_375# 0
C937 gf180mcu_fd_sc_mcu7t5v0__xnor2_1_1/A2 gf180mcu_fd_sc_mcu7t5v0__xnor2_1_1/a_930_497# 0
C938 count[2] gf180mcu_fd_sc_mcu7t5v0__dlyb_1_3/a_47_68# 0
C939 VDD gf180mcu_fd_sc_mcu7t5v0__fillcap_16_1/a_1468_375# 0.03819f
C940 gf180mcu_fd_sc_mcu7t5v0__dffq_1_2/a_1004_159# gf180mcu_fd_sc_mcu7t5v0__fillcap_32_5/a_124_375# 0.0019f
C941 gf180mcu_fd_sc_mcu7t5v0__fillcap_4_5/a_124_375# count[2] 0
C942 gf180mcu_fd_sc_mcu7t5v0__fillcap_4_6/a_124_375# gf180mcu_fd_sc_mcu7t5v0__dffq_1_0/a_2304_115# 0
C943 gf180mcu_fd_sc_mcu7t5v0__dffq_1_1/D gf180mcu_fd_sc_mcu7t5v0__dffq_1_3/a_1348_527# 0
C944 gf180mcu_fd_sc_mcu7t5v0__dffq_1_3/a_36_151# gf180mcu_fd_sc_mcu7t5v0__fillcap_16_2/a_1380_472# 0.0091f
C945 gf180mcu_fd_sc_mcu7t5v0__fillcap_32_3/a_1916_375# gf180mcu_fd_sc_mcu7t5v0__clkbuf_16_2/Z 0.06204f
C946 gf180mcu_fd_sc_mcu7t5v0__dlyb_1_0/a_47_68# gf180mcu_fd_sc_mcu7t5v0__xor2_1_0/Z 0.00374f
C947 gf180mcu_fd_sc_mcu7t5v0__dffq_1_3/a_36_151# gf180mcu_fd_sc_mcu7t5v0__clkbuf_16_2/a_224_552# 0.00231f
C948 VDD gf180mcu_fd_sc_mcu7t5v0__fillcap_16_0/a_36_472# 0.01078f
C949 gf180mcu_fd_sc_mcu7t5v0__fillcap_32_4/a_3260_375# gf180mcu_fd_sc_mcu7t5v0__fillcap_4_10/a_124_375# 0.012f
C950 clk gf180mcu_fd_sc_mcu7t5v0__fillcap_32_3/a_3172_472# 0.00593f
C951 gf180mcu_fd_sc_mcu7t5v0__fillcap_8_1/a_36_472# count[2] 0
C952 gf180mcu_fd_sc_mcu7t5v0__dffq_1_2/a_448_472# gf180mcu_fd_sc_mcu7t5v0__fillcap_32_4/a_36_472# 0.00331f
C953 gf180mcu_fd_sc_mcu7t5v0__dffq_1_2/a_36_151# gf180mcu_fd_sc_mcu7t5v0__fillcap_32_4/a_484_472# 0.01058f
C954 VDD gf180mcu_fd_sc_mcu7t5v0__fillcap_32_2/a_2276_472# -0
C955 gf180mcu_fd_sc_mcu7t5v0__fillcap_16_2/a_484_472# gf180mcu_fd_sc_mcu7t5v0__dffq_1_3/a_1376_115# 0
C956 gf180mcu_fd_sc_mcu7t5v0__xor2_1_0/Z gf180mcu_fd_sc_mcu7t5v0__dffq_1_1/a_36_151# 0.02544f
C957 gf180mcu_fd_sc_mcu7t5v0__fillcap_16_2/a_36_472# gf180mcu_fd_sc_mcu7t5v0__dffq_1_3/a_1004_159# 0.01032f
C958 gf180mcu_fd_sc_mcu7t5v0__fillcap_32_0/a_2724_472# gf180mcu_fd_sc_mcu7t5v0__fillcap_32_3/a_2276_472# 0
C959 VDD gf180mcu_fd_sc_mcu7t5v0__fillcap_32_0/a_2276_472# 0.00989f
C960 gf180mcu_fd_sc_mcu7t5v0__fillcap_8_1/a_572_375# gf180mcu_fd_sc_mcu7t5v0__fillcap_4_12/a_124_375# 0.012f
C961 gf180mcu_fd_sc_mcu7t5v0__fillcap_32_5/a_572_375# gf180mcu_fd_sc_mcu7t5v0__dffq_1_2/a_448_472# 0.0011f
C962 gf180mcu_fd_sc_mcu7t5v0__fillcap_32_5/a_1020_375# gf180mcu_fd_sc_mcu7t5v0__dffq_1_2/a_36_151# 0
C963 gf180mcu_fd_sc_mcu7t5v0__fillcap_32_6/a_2812_375# gf180mcu_fd_sc_mcu7t5v0__clkbuf_16_2/Z 0
C964 gf180mcu_fd_sc_mcu7t5v0__dffq_1_1/a_2304_115# gf180mcu_fd_sc_mcu7t5v0__dffq_1_3/a_2011_527# 0
C965 gf180mcu_fd_sc_mcu7t5v0__dlyb_1_2/a_671_644# gf180mcu_fd_sc_mcu7t5v0__xnor2_1_0/A2 0.01488f
C966 gf180mcu_fd_sc_mcu7t5v0__dlyb_1_0/a_47_68# gf180mcu_fd_sc_mcu7t5v0__dffq_1_3/a_448_472# 0.00134f
C967 gf180mcu_fd_sc_mcu7t5v0__fillcap_32_3/a_1380_472# gf180mcu_fd_sc_mcu7t5v0__fillcap_32_0/a_1468_375# 0.00154f
C968 gf180mcu_fd_sc_mcu7t5v0__clkbuf_16_0/a_224_552# gf180mcu_fd_sc_mcu7t5v0__dlyb_1_3/I 0
C969 gf180mcu_fd_sc_mcu7t5v0__dlyb_1_1/a_503_644# gf180mcu_fd_sc_mcu7t5v0__dffq_1_1/D 0
C970 gf180mcu_fd_sc_mcu7t5v0__dffq_1_2/D gf180mcu_fd_sc_mcu7t5v0__fillcap_16_0/a_36_472# 0
C971 gf180mcu_fd_sc_mcu7t5v0__xnor2_1_1/A2 gf180mcu_fd_sc_mcu7t5v0__fillcap_32_5/a_124_375# 0.00212f
C972 gf180mcu_fd_sc_mcu7t5v0__dffq_1_1/a_448_472# gf180mcu_fd_sc_mcu7t5v0__dffq_1_3/a_36_151# 0.00171f
C973 gf180mcu_fd_sc_mcu7t5v0__dffq_1_1/a_36_151# gf180mcu_fd_sc_mcu7t5v0__dffq_1_3/a_448_472# 0.00657f
C974 gf180mcu_fd_sc_mcu7t5v0__fillcap_16_0/a_484_472# gf180mcu_fd_sc_mcu7t5v0__clkbuf_16_2/Z 0.04573f
C975 gf180mcu_fd_sc_mcu7t5v0__dlyb_1_2/a_47_68# gf180mcu_fd_sc_mcu7t5v0__dffq_1_0/D 0.00327f
C976 gf180mcu_fd_sc_mcu7t5v0__fillcap_32_1/a_124_375# gf180mcu_fd_sc_mcu7t5v0__fillcap_32_3/a_36_472# 0.0027f
C977 gf180mcu_fd_sc_mcu7t5v0__dffq_1_1/a_1004_159# gf180mcu_fd_sc_mcu7t5v0__dffq_1_3/a_36_151# 0
C978 gf180mcu_fd_sc_mcu7t5v0__clkbuf_16_0/a_224_552# gf180mcu_fd_sc_mcu7t5v0__dffq_1_2/a_1376_115# 0.00165f
C979 gf180mcu_fd_sc_mcu7t5v0__fillcap_32_2/a_2724_472# gf180mcu_fd_sc_mcu7t5v0__clkbuf_16_2/Z 0.0017f
C980 gf180mcu_fd_sc_mcu7t5v0__fillcap_32_0/a_2724_472# gf180mcu_fd_sc_mcu7t5v0__clkbuf_16_2/Z 0.00876f
C981 gf180mcu_fd_sc_mcu7t5v0__fillcap_32_3/a_124_375# gf180mcu_fd_sc_mcu7t5v0__clkbuf_16_2/a_224_552# 0.0264f
C982 gf180mcu_fd_sc_mcu7t5v0__fillcap_4_2/a_36_472# gf180mcu_fd_sc_mcu7t5v0__fillcap_4_0/a_124_375# 0.0027f
C983 gf180mcu_fd_sc_mcu7t5v0__dlyb_1_1/a_503_644# gf180mcu_fd_sc_mcu7t5v0__dlyb_1_1/I 0.00146f
C984 VDD gf180mcu_fd_sc_mcu7t5v0__fillcap_32_2/a_1380_472# -0
C985 gf180mcu_fd_sc_mcu7t5v0__dffq_1_3/CLK gf180mcu_fd_sc_mcu7t5v0__fillcap_32_2/a_1468_375# 0.0013f
C986 count[1] gf180mcu_fd_sc_mcu7t5v0__dffq_1_3/a_2296_527# 0
C987 gf180mcu_fd_sc_mcu7t5v0__fillcap_32_1/a_36_472# gf180mcu_fd_sc_mcu7t5v0__dffq_1_1/a_36_151# 0.00697f
C988 clk gf180mcu_fd_sc_mcu7t5v0__fillcap_32_0/a_3260_375# 0.00112f
C989 gf180mcu_fd_sc_mcu7t5v0__dlyb_1_0/a_47_68# gf180mcu_fd_sc_mcu7t5v0__dlyb_1_0/I 0.08417f
C990 gf180mcu_fd_sc_mcu7t5v0__dffq_1_3/CLK gf180mcu_fd_sc_mcu7t5v0__dffq_1_1/a_1376_115# 0.00138f
C991 VDD gf180mcu_fd_sc_mcu7t5v0__dlyb_1_0/a_47_68# 0.02943f
C992 VDD gf180mcu_fd_sc_mcu7t5v0__fillcap_32_2/a_572_375# 0
C993 gf180mcu_fd_sc_mcu7t5v0__fillcap_32_1/a_1468_375# gf180mcu_fd_sc_mcu7t5v0__fillcap_32_0/a_1468_375# 0
C994 gf180mcu_fd_sc_mcu7t5v0__dlyb_1_0/I gf180mcu_fd_sc_mcu7t5v0__dffq_1_1/a_36_151# 0.00527f
C995 gf180mcu_fd_sc_mcu7t5v0__fillcap_32_3/a_3260_375# gf180mcu_fd_sc_mcu7t5v0__clkbuf_16_2/Z 0.00258f
C996 VDD gf180mcu_fd_sc_mcu7t5v0__dffq_1_1/a_36_151# 0.07959f
C997 gf180mcu_fd_sc_mcu7t5v0__clkbuf_16_2/a_224_552# gf180mcu_fd_sc_mcu7t5v0__clkbuf_16_2/Z 0.18562f
C998 gf180mcu_fd_sc_mcu7t5v0__dlyb_1_1/a_895_68# count[0] 0.02298f
C999 gf180mcu_fd_sc_mcu7t5v0__nand3_1_0/a_271_68# gf180mcu_fd_sc_mcu7t5v0__dlyb_1_0/I 0.00177f
C1000 VDD gf180mcu_fd_sc_mcu7t5v0__fillcap_32_4/a_572_375# 0.00371f
C1001 VDD gf180mcu_fd_sc_mcu7t5v0__fillcap_32_4/a_1828_472# -0
C1002 VDD gf180mcu_fd_sc_mcu7t5v0__fillcap_32_1/a_3260_375# 0.02248f
C1003 VDD gf180mcu_fd_sc_mcu7t5v0__nand3_1_0/a_271_68# -0
C1004 gf180mcu_fd_sc_mcu7t5v0__fillcap_4_5/a_36_472# count[2] 0.00183f
C1005 gf180mcu_fd_sc_mcu7t5v0__dlyb_1_0/a_1127_622# gf180mcu_fd_sc_mcu7t5v0__fillcap_16_2/a_36_472# 0
C1006 clk gf180mcu_fd_sc_mcu7t5v0__fillcap_32_5/a_1828_472# 0.00694f
C1007 gf180mcu_fd_sc_mcu7t5v0__dffq_1_1/D gf180mcu_fd_sc_mcu7t5v0__dffq_1_1/a_1376_115# 0.04119f
C1008 count[2] gf180mcu_fd_sc_mcu7t5v0__xnor2_1_0/A2 0.00475f
C1009 gf180mcu_fd_sc_mcu7t5v0__dlyb_1_2/a_47_68# gf180mcu_fd_sc_mcu7t5v0__xnor2_1_0/A2 0.00201f
C1010 VDD gf180mcu_fd_sc_mcu7t5v0__xnor2_1_1/a_716_68# 0.01367f
C1011 VDD gf180mcu_fd_sc_mcu7t5v0__fillcap_16_0/a_1020_375# -0.01464f
C1012 gf180mcu_fd_sc_mcu7t5v0__dlyb_1_1/I gf180mcu_fd_sc_mcu7t5v0__dffq_1_1/a_2256_159# 0
C1013 VDD gf180mcu_fd_sc_mcu7t5v0__fillcap_32_6/a_1916_375# 0
C1014 gf180mcu_fd_sc_mcu7t5v0__xor2_1_0/Z gf180mcu_fd_sc_mcu7t5v0__dffq_1_3/a_1348_527# 0
C1015 gf180mcu_fd_sc_mcu7t5v0__dffq_1_2/CLK gf180mcu_fd_sc_mcu7t5v0__fillcap_16_1/a_1380_472# 0.00221f
C1016 VDD gf180mcu_fd_sc_mcu7t5v0__fillcap_8_0/a_124_375# 0.0135f
C1017 gf180mcu_fd_sc_mcu7t5v0__fillcap_32_2/a_3260_375# gf180mcu_fd_sc_mcu7t5v0__fillcap_4_1/a_36_472# 0.01675f
C1018 VDD gf180mcu_fd_sc_mcu7t5v0__dlyb_1_1/a_1127_622# 0
C1019 gf180mcu_fd_sc_mcu7t5v0__fillcap_32_0/a_1020_375# gf180mcu_fd_sc_mcu7t5v0__clkbuf_16_2/a_224_552# 0
C1020 gf180mcu_fd_sc_mcu7t5v0__fillcap_32_4/a_1020_375# gf180mcu_fd_sc_mcu7t5v0__clkbuf_16_2/Z 0.00365f
C1021 gf180mcu_fd_sc_mcu7t5v0__dlyb_1_0/a_671_644# gf180mcu_fd_sc_mcu7t5v0__dlyb_1_0/I 0.03232f
C1022 VDD gf180mcu_fd_sc_mcu7t5v0__dlyb_1_0/a_671_644# 0.02469f
C1023 gf180mcu_fd_sc_mcu7t5v0__dlyb_1_1/I gf180mcu_fd_sc_mcu7t5v0__dffq_1_1/a_1376_115# 0.00133f
C1024 VDD gf180mcu_fd_sc_mcu7t5v0__fillcap_32_6/a_572_375# 0
C1025 gf180mcu_fd_sc_mcu7t5v0__dffq_1_1/D gf180mcu_fd_sc_mcu7t5v0__fillcap_8_0/a_36_472# 0.10608f
C1026 gf180mcu_fd_sc_mcu7t5v0__clkbuf_16_1/a_224_552# gf180mcu_fd_sc_mcu7t5v0__fillcap_32_0/a_1916_375# 0
C1027 gf180mcu_fd_sc_mcu7t5v0__dffq_1_2/D gf180mcu_fd_sc_mcu7t5v0__xnor2_1_1/a_716_68# 0.00289f
C1028 gf180mcu_fd_sc_mcu7t5v0__fillcap_32_5/a_932_472# gf180mcu_fd_sc_mcu7t5v0__clkbuf_16_2/a_224_552# 0.0143f
C1029 gf180mcu_fd_sc_mcu7t5v0__dlyb_1_3/a_503_644# gf180mcu_fd_sc_mcu7t5v0__xnor2_1_0/A2 0.00144f
C1030 gf180mcu_fd_sc_mcu7t5v0__dlyb_1_2/a_671_644# count[3] 0.00401f
C1031 gf180mcu_fd_sc_mcu7t5v0__fillcap_32_1/a_2812_375# gf180mcu_fd_sc_mcu7t5v0__fillcap_32_0/a_3260_375# 0
C1032 gf180mcu_fd_sc_mcu7t5v0__fillcap_16_2/a_124_375# gf180mcu_fd_sc_mcu7t5v0__xnor2_1_1/a_64_93# 0
C1033 gf180mcu_fd_sc_mcu7t5v0__clkbuf_16_0/a_224_552# gf180mcu_fd_sc_mcu7t5v0__dffq_1_0/a_36_151# 0.01626f
C1034 gf180mcu_fd_sc_mcu7t5v0__fillcap_32_0/a_124_375# gf180mcu_fd_sc_mcu7t5v0__clkbuf_16_1/a_224_552# 0.00222f
C1035 gf180mcu_fd_sc_mcu7t5v0__clkbuf_16_0/a_224_552# gf180mcu_fd_sc_mcu7t5v0__dlyb_1_2/I 0.00367f
C1036 gf180mcu_fd_sc_mcu7t5v0__xnor2_1_0/a_64_93# gf180mcu_fd_sc_mcu7t5v0__fillcap_4_5/a_124_375# 0.1331f
C1037 VDD gf180mcu_fd_sc_mcu7t5v0__fillcap_32_6/a_1380_472# -0
C1038 gf180mcu_fd_sc_mcu7t5v0__dlyb_1_1/I gf180mcu_fd_sc_mcu7t5v0__fillcap_8_0/a_36_472# 0.00803f
C1039 VDD gf180mcu_fd_sc_mcu7t5v0__fillcap_32_3/a_2364_375# 0.01345f
C1040 count[2] gf180mcu_fd_sc_mcu7t5v0__dlyb_1_3/I 0.01873f
C1041 clk gf180mcu_fd_sc_mcu7t5v0__fillcap_32_5/a_3172_472# 0.01949f
C1042 gf180mcu_fd_sc_mcu7t5v0__fillcap_8_1/a_572_375# gf180mcu_fd_sc_mcu7t5v0__dlyb_1_1/I 0.04036f
C1043 gf180mcu_fd_sc_mcu7t5v0__dlyb_1_1/a_47_68# count[0] 0.00192f
C1044 gf180mcu_fd_sc_mcu7t5v0__fillcap_32_4/a_2276_472# gf180mcu_fd_sc_mcu7t5v0__clkbuf_16_2/Z 0.01832f
C1045 VDD gf180mcu_fd_sc_mcu7t5v0__dffq_1_3/a_1348_527# 0
C1046 gf180mcu_fd_sc_mcu7t5v0__dffq_1_2/CLK gf180mcu_fd_sc_mcu7t5v0__dffq_1_0/a_1376_115# 0
C1047 gf180mcu_fd_sc_mcu7t5v0__xor2_1_0/a_56_604# gf180mcu_fd_sc_mcu7t5v0__fillcap_4_4/a_36_472# 0.00744f
C1048 gf180mcu_fd_sc_mcu7t5v0__fillcap_32_3/a_572_375# gf180mcu_fd_sc_mcu7t5v0__fillcap_32_0/a_932_472# 0.00154f
C1049 gf180mcu_fd_sc_mcu7t5v0__dffq_1_2/CLK gf180mcu_fd_sc_mcu7t5v0__fillcap_32_4/a_932_472# 0.06895f
C1050 VDD gf180mcu_fd_sc_mcu7t5v0__fillcap_32_6/a_3260_375# 0.02932f
C1051 gf180mcu_fd_sc_mcu7t5v0__xnor2_1_1/A2 gf180mcu_fd_sc_mcu7t5v0__xnor2_1_1/a_716_68# 0.00625f
C1052 gf180mcu_fd_sc_mcu7t5v0__fillcap_32_2/a_3260_375# gf180mcu_fd_sc_mcu7t5v0__clkbuf_16_2/Z 0.03241f
C1053 gf180mcu_fd_sc_mcu7t5v0__xor2_1_0/Z gf180mcu_fd_sc_mcu7t5v0__dffq_1_1/a_2256_159# 0
C1054 gf180mcu_fd_sc_mcu7t5v0__fillcap_32_3/a_2812_375# gf180mcu_fd_sc_mcu7t5v0__clkbuf_16_2/Z 0.0052f
C1055 gf180mcu_fd_sc_mcu7t5v0__fillcap_4_7/a_124_375# gf180mcu_fd_sc_mcu7t5v0__dlyb_1_3/a_47_68# 0.00148f
C1056 gf180mcu_fd_sc_mcu7t5v0__dlyb_1_3/I gf180mcu_fd_sc_mcu7t5v0__dffq_1_2/a_448_472# 0.00272f
C1057 gf180mcu_fd_sc_mcu7t5v0__fillcap_32_6/a_1828_472# gf180mcu_fd_sc_mcu7t5v0__clkbuf_16_2/Z 0.00318f
C1058 gf180mcu_fd_sc_mcu7t5v0__dffq_1_2/CLK gf180mcu_fd_sc_mcu7t5v0__fillcap_16_0/a_124_375# 0.00738f
C1059 gf180mcu_fd_sc_mcu7t5v0__fillcap_32_1/a_1828_472# gf180mcu_fd_sc_mcu7t5v0__clkbuf_16_1/a_224_552# 0.00146f
C1060 gf180mcu_fd_sc_mcu7t5v0__dlyb_1_3/a_503_644# gf180mcu_fd_sc_mcu7t5v0__dlyb_1_3/I 0
C1061 gf180mcu_fd_sc_mcu7t5v0__fillcap_32_5/a_2276_472# gf180mcu_fd_sc_mcu7t5v0__clkbuf_16_2/a_224_552# 0.00104f
C1062 gf180mcu_fd_sc_mcu7t5v0__dlyb_1_3/a_47_68# gf180mcu_fd_sc_mcu7t5v0__fillcap_4_12/a_36_472# 0
C1063 gf180mcu_fd_sc_mcu7t5v0__xnor2_1_0/a_64_93# gf180mcu_fd_sc_mcu7t5v0__dffq_1_0/D 0
C1064 gf180mcu_fd_sc_mcu7t5v0__dffq_1_3/a_1376_115# gf180mcu_fd_sc_mcu7t5v0__clkbuf_16_2/a_224_552# 0.0014f
C1065 gf180mcu_fd_sc_mcu7t5v0__fillcap_32_3/a_932_472# gf180mcu_fd_sc_mcu7t5v0__clkbuf_16_2/Z 0.00542f
C1066 gf180mcu_fd_sc_mcu7t5v0__dlyb_1_2/a_671_644# gf180mcu_fd_sc_mcu7t5v0__dlyb_1_2/I 0.02459f
C1067 gf180mcu_fd_sc_mcu7t5v0__fillcap_8_1/a_36_472# count[1] 0.00458f
C1068 gf180mcu_fd_sc_mcu7t5v0__dffq_1_2/CLK gf180mcu_fd_sc_mcu7t5v0__fillcap_32_6/a_1020_375# 0
C1069 clk gf180mcu_fd_sc_mcu7t5v0__fillcap_4_2/a_124_375# 0.00722f
C1070 VDD gf180mcu_fd_sc_mcu7t5v0__dlyb_1_1/a_503_644# 0
C1071 VDD gf180mcu_fd_sc_mcu7t5v0__fillcap_32_2/a_3172_472# 0.00582f
C1072 gf180mcu_fd_sc_mcu7t5v0__xor2_1_0/Z gf180mcu_fd_sc_mcu7t5v0__dffq_1_1/a_1376_115# 0.0427f
C1073 clk gf180mcu_fd_sc_mcu7t5v0__fillcap_32_5/a_3260_375# 0.00659f
C1074 gf180mcu_fd_sc_mcu7t5v0__dlyb_1_2/a_47_68# count[3] 0.0018f
C1075 gf180mcu_fd_sc_mcu7t5v0__xor2_1_0/a_56_604# gf180mcu_fd_sc_mcu7t5v0__dffq_1_3/a_2011_527# 0
C1076 gf180mcu_fd_sc_mcu7t5v0__fillcap_32_3/a_1828_472# gf180mcu_fd_sc_mcu7t5v0__fillcap_32_0/a_1916_375# 0.00154f
C1077 gf180mcu_fd_sc_mcu7t5v0__fillcap_8_1/a_36_472# gf180mcu_fd_sc_mcu7t5v0__fillcap_4_6/a_36_472# 0.05841f
C1078 gf180mcu_fd_sc_mcu7t5v0__clkbuf_16_1/a_224_552# gf180mcu_fd_sc_mcu7t5v0__dffq_1_3/a_36_151# 0.00199f
C1079 VDD gf180mcu_fd_sc_mcu7t5v0__fillcap_4_11/a_36_472# 0.11579f
C1080 gf180mcu_fd_sc_mcu7t5v0__fillcap_32_0/a_1020_375# gf180mcu_fd_sc_mcu7t5v0__fillcap_32_3/a_932_472# 0.00154f
C1081 VDD gf180mcu_fd_sc_mcu7t5v0__fillcap_32_3/a_36_472# 0.12419f
C1082 gf180mcu_fd_sc_mcu7t5v0__fillcap_32_1/a_572_375# gf180mcu_fd_sc_mcu7t5v0__fillcap_32_3/a_484_472# 0.0027f
C1083 gf180mcu_fd_sc_mcu7t5v0__fillcap_16_2/a_124_375# gf180mcu_fd_sc_mcu7t5v0__dffq_1_1/D 0
C1084 gf180mcu_fd_sc_mcu7t5v0__fillcap_32_4/a_3172_472# gf180mcu_fd_sc_mcu7t5v0__fillcap_4_10/a_36_472# 0.01328f
C1085 gf180mcu_fd_sc_mcu7t5v0__fillcap_4_5/a_36_472# gf180mcu_fd_sc_mcu7t5v0__xnor2_1_0/a_64_93# 0.00685f
C1086 gf180mcu_fd_sc_mcu7t5v0__dlyb_1_0/I gf180mcu_fd_sc_mcu7t5v0__dffq_1_1/a_2256_159# 0
C1087 gf180mcu_fd_sc_mcu7t5v0__fillcap_32_1/a_1020_375# gf180mcu_fd_sc_mcu7t5v0__clkbuf_16_2/Z 0.0048f
C1088 VDD gf180mcu_fd_sc_mcu7t5v0__dffq_1_1/a_2256_159# 0
C1089 gf180mcu_fd_sc_mcu7t5v0__xnor2_1_0/a_64_93# gf180mcu_fd_sc_mcu7t5v0__xnor2_1_0/A2 0.00397f
C1090 gf180mcu_fd_sc_mcu7t5v0__dffq_1_2/D gf180mcu_fd_sc_mcu7t5v0__fillcap_32_3/a_36_472# 0
C1091 gf180mcu_fd_sc_mcu7t5v0__clkbuf_16_1/a_224_552# gf180mcu_fd_sc_mcu7t5v0__fillcap_32_1/a_572_375# 0.00118f
C1092 gf180mcu_fd_sc_mcu7t5v0__fillcap_32_2/a_124_375# gf180mcu_fd_sc_mcu7t5v0__dffq_1_3/CLK 0.00151f
C1093 VDD gf180mcu_fd_sc_mcu7t5v0__fillcap_32_2/a_1468_375# 0
C1094 gf180mcu_fd_sc_mcu7t5v0__fillcap_32_1/a_1916_375# gf180mcu_fd_sc_mcu7t5v0__fillcap_32_0/a_1916_375# 0
C1095 gf180mcu_fd_sc_mcu7t5v0__dlyb_1_0/I gf180mcu_fd_sc_mcu7t5v0__fillcap_16_2/a_1020_375# 0.00198f
C1096 gf180mcu_fd_sc_mcu7t5v0__fillcap_32_3/a_484_472# gf180mcu_fd_sc_mcu7t5v0__clkbuf_16_2/Z 0.00187f
C1097 gf180mcu_fd_sc_mcu7t5v0__dlyb_1_2/a_47_68# gf180mcu_fd_sc_mcu7t5v0__dffq_1_0/a_36_151# 0.00109f
C1098 gf180mcu_fd_sc_mcu7t5v0__clkbuf_16_0/a_224_552# gf180mcu_fd_sc_mcu7t5v0__fillcap_16_1/a_124_375# 0
C1099 gf180mcu_fd_sc_mcu7t5v0__xor2_1_0/a_56_604# gf180mcu_fd_sc_mcu7t5v0__dffq_1_1/a_2304_115# 0.00415f
C1100 gf180mcu_fd_sc_mcu7t5v0__dlyb_1_0/a_47_68# gf180mcu_fd_sc_mcu7t5v0__dffq_1_1/a_2011_527# 0
C1101 VDD gf180mcu_fd_sc_mcu7t5v0__dffq_1_1/a_1376_115# 0.0108f
C1102 VDD gf180mcu_fd_sc_mcu7t5v0__fillcap_16_2/a_1020_375# 0.05435f
C1103 count[2] gf180mcu_fd_sc_mcu7t5v0__dlyb_1_2/I 0
C1104 gf180mcu_fd_sc_mcu7t5v0__dlyb_1_2/a_47_68# gf180mcu_fd_sc_mcu7t5v0__dlyb_1_2/I 0.05481f
C1105 gf180mcu_fd_sc_mcu7t5v0__dlyb_1_1/a_523_68# count[0] 0
C1106 gf180mcu_fd_sc_mcu7t5v0__dffq_1_2/CLK gf180mcu_fd_sc_mcu7t5v0__fillcap_16_1/a_1468_375# 0.00135f
C1107 VDD gf180mcu_fd_sc_mcu7t5v0__fillcap_32_4/a_1468_375# 0.00371f
C1108 gf180mcu_fd_sc_mcu7t5v0__fillcap_32_0/a_1020_375# gf180mcu_fd_sc_mcu7t5v0__fillcap_32_1/a_1020_375# 0
C1109 VDD gf180mcu_fd_sc_mcu7t5v0__fillcap_32_4/a_3260_375# 0.00293f
C1110 gf180mcu_fd_sc_mcu7t5v0__dffq_1_2/a_2011_527# gf180mcu_fd_sc_mcu7t5v0__clkbuf_16_2/a_224_552# 0
C1111 gf180mcu_fd_sc_mcu7t5v0__dffq_1_2/CLK gf180mcu_fd_sc_mcu7t5v0__fillcap_16_0/a_36_472# 0.03724f
C1112 VDD gf180mcu_fd_sc_mcu7t5v0__fillcap_16_0/a_932_472# 0
C1113 gf180mcu_fd_sc_mcu7t5v0__fillcap_4_7/a_124_375# gf180mcu_fd_sc_mcu7t5v0__xnor2_1_0/A2 0.00354f
C1114 gf180mcu_fd_sc_mcu7t5v0__clkbuf_16_1/a_224_552# gf180mcu_fd_sc_mcu7t5v0__clkbuf_16_2/Z 0.06431f
C1115 gf180mcu_fd_sc_mcu7t5v0__dlyb_1_3/a_47_68# gf180mcu_fd_sc_mcu7t5v0__dffq_1_0/a_1004_159# 0
C1116 gf180mcu_fd_sc_mcu7t5v0__dffq_1_0/a_448_472# gf180mcu_fd_sc_mcu7t5v0__fillcap_32_4/a_36_472# 0
C1117 gf180mcu_fd_sc_mcu7t5v0__xnor2_1_0/A2 gf180mcu_fd_sc_mcu7t5v0__fillcap_4_12/a_36_472# 0
C1118 gf180mcu_fd_sc_mcu7t5v0__fillcap_32_5/a_1916_375# gf180mcu_fd_sc_mcu7t5v0__clkbuf_16_2/Z 0.06125f
C1119 gf180mcu_fd_sc_mcu7t5v0__dffq_1_0/a_36_151# gf180mcu_fd_sc_mcu7t5v0__dffq_1_2/a_448_472# 0.00146f
C1120 VDD gf180mcu_fd_sc_mcu7t5v0__fillcap_8_0/a_36_472# 0.01162f
C1121 gf180mcu_fd_sc_mcu7t5v0__clkbuf_16_1/a_224_552# gf180mcu_fd_sc_mcu7t5v0__fillcap_32_1/a_3172_472# 0
C1122 gf180mcu_fd_sc_mcu7t5v0__xnor2_1_0/A2 gf180mcu_fd_sc_mcu7t5v0__fillcap_4_6/a_36_472# 0.00353f
C1123 gf180mcu_fd_sc_mcu7t5v0__fillcap_8_1/a_572_375# gf180mcu_fd_sc_mcu7t5v0__dlyb_1_0/I 0.0064f
C1124 gf180mcu_fd_sc_mcu7t5v0__dffq_1_0/a_448_472# gf180mcu_fd_sc_mcu7t5v0__dlyb_1_3/a_47_68# 0.00544f
C1125 gf180mcu_fd_sc_mcu7t5v0__fillcap_16_0/a_1380_472# gf180mcu_fd_sc_mcu7t5v0__fillcap_4_9/a_36_472# 0.01328f
C1126 gf180mcu_fd_sc_mcu7t5v0__xnor2_1_0/a_64_93# gf180mcu_fd_sc_mcu7t5v0__dlyb_1_3/I 0.00103f
C1127 VDD gf180mcu_fd_sc_mcu7t5v0__fillcap_32_6/a_36_472# 0.10495f
C1128 VDD gf180mcu_fd_sc_mcu7t5v0__fillcap_8_1/a_572_375# 0.00173f
C1129 VDD gf180mcu_fd_sc_mcu7t5v0__clkbuf_16_0/a_224_552# 0.23314f
C1130 gf180mcu_fd_sc_mcu7t5v0__fillcap_32_5/a_1828_472# gf180mcu_fd_sc_mcu7t5v0__clkbuf_16_2/a_224_552# 0.00146f
C1131 gf180mcu_fd_sc_mcu7t5v0__dffq_1_2/a_36_151# gf180mcu_fd_sc_mcu7t5v0__clkbuf_16_2/Z 0.00428f
C1132 gf180mcu_fd_sc_mcu7t5v0__fillcap_32_5/a_572_375# gf180mcu_fd_sc_mcu7t5v0__clkbuf_16_2/Z 0.00241f
C1133 gf180mcu_fd_sc_mcu7t5v0__fillcap_16_0/a_1380_472# gf180mcu_fd_sc_mcu7t5v0__clkbuf_16_2/Z 0.00534f
C1134 gf180mcu_fd_sc_mcu7t5v0__dlyb_1_0/a_671_644# gf180mcu_fd_sc_mcu7t5v0__dffq_1_1/a_2011_527# 0
C1135 VDD gf180mcu_fd_sc_mcu7t5v0__fillcap_32_4/a_2724_472# -0
C1136 gf180mcu_fd_sc_mcu7t5v0__fillcap_32_0/a_1020_375# gf180mcu_fd_sc_mcu7t5v0__clkbuf_16_1/a_224_552# 0.00222f
C1137 gf180mcu_fd_sc_mcu7t5v0__dlyb_1_1/I gf180mcu_fd_sc_mcu7t5v0__dlyb_1_3/a_503_644# 0
C1138 gf180mcu_fd_sc_mcu7t5v0__fillcap_32_5/a_36_472# gf180mcu_fd_sc_mcu7t5v0__fillcap_32_5/a_124_375# 0
C1139 gf180mcu_fd_sc_mcu7t5v0__dlyb_1_2/a_503_644# gf180mcu_fd_sc_mcu7t5v0__fillcap_16_1/a_36_472# 0
C1140 gf180mcu_fd_sc_mcu7t5v0__clkbuf_16_0/a_224_552# gf180mcu_fd_sc_mcu7t5v0__dffq_1_2/D 0.00158f
C1141 gf180mcu_fd_sc_mcu7t5v0__xnor2_1_1/a_716_68# gf180mcu_fd_sc_mcu7t5v0__dffq_1_2/a_2304_115# 0
C1142 VDD gf180mcu_fd_sc_mcu7t5v0__fillcap_32_2/a_36_472# 0.10495f
C1143 gf180mcu_fd_sc_mcu7t5v0__fillcap_4_9/a_36_472# gf180mcu_fd_sc_mcu7t5v0__fillcap_32_4/a_3172_472# 0.05841f
C1144 VDD gf180mcu_fd_sc_mcu7t5v0__fillcap_32_6/a_2276_472# -0
C1145 clk gf180mcu_fd_sc_mcu7t5v0__fillcap_16_0/a_1468_375# 0.00308f
C1146 gf180mcu_fd_sc_mcu7t5v0__dffq_1_0/a_1004_159# gf180mcu_fd_sc_mcu7t5v0__dffq_1_0/D 0.02376f
C1147 VDD gf180mcu_fd_sc_mcu7t5v0__fillcap_32_3/a_1380_472# 0.01856f
C1148 gf180mcu_fd_sc_mcu7t5v0__fillcap_4_7/a_124_375# gf180mcu_fd_sc_mcu7t5v0__dlyb_1_3/I 0.02046f
C1149 gf180mcu_fd_sc_mcu7t5v0__fillcap_16_2/a_124_375# gf180mcu_fd_sc_mcu7t5v0__xor2_1_0/Z 0.00525f
C1150 gf180mcu_fd_sc_mcu7t5v0__fillcap_8_1/a_484_472# gf180mcu_fd_sc_mcu7t5v0__dlyb_1_1/I 0.06774f
C1151 gf180mcu_fd_sc_mcu7t5v0__dffq_1_0/a_448_472# gf180mcu_fd_sc_mcu7t5v0__dffq_1_0/D 0.01507f
C1152 gf180mcu_fd_sc_mcu7t5v0__dlyb_1_3/I gf180mcu_fd_sc_mcu7t5v0__fillcap_4_12/a_36_472# 0.00543f
C1153 gf180mcu_fd_sc_mcu7t5v0__dlyb_1_1/a_671_644# count[0] 0.01052f
C1154 gf180mcu_fd_sc_mcu7t5v0__fillcap_32_4/a_3172_472# gf180mcu_fd_sc_mcu7t5v0__clkbuf_16_2/Z 0.00295f
C1155 VDD gf180mcu_fd_sc_mcu7t5v0__dffq_1_3/a_836_159# 0
C1156 gf180mcu_fd_sc_mcu7t5v0__fillcap_4_7/a_124_375# gf180mcu_fd_sc_mcu7t5v0__xnor2_1_1/a_64_93# 0.13277f
C1157 gf180mcu_fd_sc_mcu7t5v0__clkbuf_16_0/a_224_552# gf180mcu_fd_sc_mcu7t5v0__dffq_1_2/a_1004_159# 0.00187f
C1158 gf180mcu_fd_sc_mcu7t5v0__fillcap_32_3/a_1020_375# gf180mcu_fd_sc_mcu7t5v0__fillcap_32_0/a_1380_472# 0.00154f
C1159 gf180mcu_fd_sc_mcu7t5v0__dlyb_1_3/I gf180mcu_fd_sc_mcu7t5v0__fillcap_4_6/a_36_472# 0.00518f
C1160 gf180mcu_fd_sc_mcu7t5v0__fillcap_32_5/a_932_472# gf180mcu_fd_sc_mcu7t5v0__dffq_1_2/a_36_151# 0.00123f
C1161 gf180mcu_fd_sc_mcu7t5v0__dffq_1_2/CLK gf180mcu_fd_sc_mcu7t5v0__fillcap_32_4/a_572_375# 0.02363f
C1162 gf180mcu_fd_sc_mcu7t5v0__dffq_1_2/CLK gf180mcu_fd_sc_mcu7t5v0__fillcap_32_4/a_1828_472# 0.00341f
C1163 gf180mcu_fd_sc_mcu7t5v0__dlyb_1_2/a_671_644# VDD 0.00622f
C1164 gf180mcu_fd_sc_mcu7t5v0__dlyb_1_2/a_671_644# gf180mcu_fd_sc_mcu7t5v0__dffq_1_0/a_2011_527# 0
C1165 gf180mcu_fd_sc_mcu7t5v0__dffq_1_2/CLK gf180mcu_fd_sc_mcu7t5v0__fillcap_16_0/a_1020_375# 0
C1166 gf180mcu_fd_sc_mcu7t5v0__fillcap_32_5/a_3172_472# gf180mcu_fd_sc_mcu7t5v0__clkbuf_16_2/a_224_552# 0
C1167 gf180mcu_fd_sc_mcu7t5v0__fillcap_32_3/a_1828_472# gf180mcu_fd_sc_mcu7t5v0__clkbuf_16_2/Z 0.04948f
C1168 gf180mcu_fd_sc_mcu7t5v0__dffq_1_0/a_2296_527# gf180mcu_fd_sc_mcu7t5v0__xnor2_1_0/A2 0
C1169 gf180mcu_fd_sc_mcu7t5v0__xnor2_1_0/a_716_68# gf180mcu_fd_sc_mcu7t5v0__dffq_1_0/D 0.00227f
C1170 gf180mcu_fd_sc_mcu7t5v0__dlyb_1_2/a_47_68# gf180mcu_fd_sc_mcu7t5v0__fillcap_16_1/a_124_375# 0.00653f
C1171 VDD gf180mcu_fd_sc_mcu7t5v0__fillcap_32_1/a_1468_375# 0.02153f
C1172 gf180mcu_fd_sc_mcu7t5v0__fillcap_4_2/a_36_472# gf180mcu_fd_sc_mcu7t5v0__clkbuf_16_2/Z 0
C1173 gf180mcu_fd_sc_mcu7t5v0__dlyb_1_1/I gf180mcu_fd_sc_mcu7t5v0__dffq_1_3/a_2256_159# 0
C1174 gf180mcu_fd_sc_mcu7t5v0__dffq_1_0/a_1004_159# gf180mcu_fd_sc_mcu7t5v0__xnor2_1_0/A2 0.01143f
C1175 gf180mcu_fd_sc_mcu7t5v0__dlyb_1_1/a_47_68# gf180mcu_fd_sc_mcu7t5v0__dffq_1_1/a_2304_115# 0.0011f
C1176 gf180mcu_fd_sc_mcu7t5v0__dlyb_1_1/I gf180mcu_fd_sc_mcu7t5v0__dlyb_1_0/a_1147_68# 0
C1177 gf180mcu_fd_sc_mcu7t5v0__fillcap_16_2/a_124_375# gf180mcu_fd_sc_mcu7t5v0__dlyb_1_0/I 0.01511f
C1178 gf180mcu_fd_sc_mcu7t5v0__dffq_1_0/a_448_472# gf180mcu_fd_sc_mcu7t5v0__xnor2_1_0/A2 0.05223f
C1179 gf180mcu_fd_sc_mcu7t5v0__fillcap_32_0/a_124_375# gf180mcu_fd_sc_mcu7t5v0__dffq_1_3/CLK 0.01313f
C1180 VDD gf180mcu_fd_sc_mcu7t5v0__fillcap_16_2/a_124_375# 0.03943f
C1181 gf180mcu_fd_sc_mcu7t5v0__dffq_1_1/a_448_472# gf180mcu_fd_sc_mcu7t5v0__dffq_1_3/a_2011_527# 0
C1182 gf180mcu_fd_sc_mcu7t5v0__xnor2_1_0/a_64_93# gf180mcu_fd_sc_mcu7t5v0__dlyb_1_2/I 0.08478f
C1183 gf180mcu_fd_sc_mcu7t5v0__fillcap_4_2/a_124_375# gf180mcu_fd_sc_mcu7t5v0__fillcap_32_3/a_3260_375# 0.012f
C1184 VDD gf180mcu_fd_sc_mcu7t5v0__fillcap_4_0/a_124_375# 0.04817f
C1185 gf180mcu_fd_sc_mcu7t5v0__fillcap_32_0/a_124_375# gf180mcu_fd_sc_mcu7t5v0__fillcap_32_1/a_124_375# 0
C1186 gf180mcu_fd_sc_mcu7t5v0__dlyb_1_1/I gf180mcu_fd_sc_mcu7t5v0__dffq_1_3/a_2304_115# 0.02141f
C1187 gf180mcu_fd_sc_mcu7t5v0__fillcap_16_0/a_36_472# gf180mcu_fd_sc_mcu7t5v0__fillcap_16_0/a_124_375# 0
C1188 gf180mcu_fd_sc_mcu7t5v0__fillcap_32_1/a_1916_375# gf180mcu_fd_sc_mcu7t5v0__clkbuf_16_2/Z 0.05832f
C1189 gf180mcu_fd_sc_mcu7t5v0__fillcap_4_3/a_36_472# gf180mcu_fd_sc_mcu7t5v0__dffq_1_3/a_2304_115# 0.00545f
C1190 gf180mcu_fd_sc_mcu7t5v0__fillcap_16_2/a_1468_375# gf180mcu_fd_sc_mcu7t5v0__clkbuf_16_2/a_224_552# 0.03233f
C1191 gf180mcu_fd_sc_mcu7t5v0__fillcap_32_1/a_484_472# gf180mcu_fd_sc_mcu7t5v0__clkbuf_16_1/a_224_552# 0.01432f
C1192 gf180mcu_fd_sc_mcu7t5v0__fillcap_32_6/a_1380_472# gf180mcu_fd_sc_mcu7t5v0__dffq_1_2/CLK 0
C1193 clk gf180mcu_fd_sc_mcu7t5v0__fillcap_16_0/a_572_375# 0
C1194 gf180mcu_fd_sc_mcu7t5v0__dffq_1_0/a_2296_527# gf180mcu_fd_sc_mcu7t5v0__dlyb_1_3/I 0
C1195 VDD count[2] 0.16385f
C1196 VDD gf180mcu_fd_sc_mcu7t5v0__dlyb_1_2/a_47_68# 0.00322f
C1197 gf180mcu_fd_sc_mcu7t5v0__fillcap_32_3/a_1468_375# gf180mcu_fd_sc_mcu7t5v0__fillcap_32_0/a_1828_472# 0.00154f
C1198 gf180mcu_fd_sc_mcu7t5v0__dlyb_1_2/a_47_68# gf180mcu_fd_sc_mcu7t5v0__dffq_1_0/a_2011_527# 0
C1199 gf180mcu_fd_sc_mcu7t5v0__fillcap_32_2/a_1916_375# gf180mcu_fd_sc_mcu7t5v0__clkbuf_16_1/a_224_552# 0
C1200 gf180mcu_fd_sc_mcu7t5v0__fillcap_16_2/a_572_375# gf180mcu_fd_sc_mcu7t5v0__clkbuf_16_2/Z 0.00167f
C1201 gf180mcu_fd_sc_mcu7t5v0__fillcap_32_0/a_1468_375# gf180mcu_fd_sc_mcu7t5v0__clkbuf_16_2/Z 0.00798f
C1202 gf180mcu_fd_sc_mcu7t5v0__xnor2_1_0/a_716_68# gf180mcu_fd_sc_mcu7t5v0__xnor2_1_0/A2 0
C1203 gf180mcu_fd_sc_mcu7t5v0__dlyb_1_0/a_47_68# gf180mcu_fd_sc_mcu7t5v0__fillcap_16_2/a_36_472# 0.17126f
C1204 VDD gf180mcu_fd_sc_mcu7t5v0__fillcap_32_5/a_2364_375# -0.01464f
C1205 gf180mcu_fd_sc_mcu7t5v0__dffq_1_0/a_1004_159# gf180mcu_fd_sc_mcu7t5v0__dlyb_1_3/I 0.01253f
C1206 gf180mcu_fd_sc_mcu7t5v0__dffq_1_0/a_36_151# gf180mcu_fd_sc_mcu7t5v0__fillcap_4_7/a_124_375# 0
C1207 VDD gf180mcu_fd_sc_mcu7t5v0__fillcap_32_2/a_124_375# 0.00993f
C1208 gf180mcu_fd_sc_mcu7t5v0__dffq_1_0/a_448_472# gf180mcu_fd_sc_mcu7t5v0__dlyb_1_3/I 0.00908f
C1209 VDD gf180mcu_fd_sc_mcu7t5v0__fillcap_32_4/a_484_472# -0
C1210 gf180mcu_fd_sc_mcu7t5v0__clkbuf_16_0/a_224_552# gf180mcu_fd_sc_mcu7t5v0__fillcap_16_1/a_484_472# 0.01591f
C1211 gf180mcu_fd_sc_mcu7t5v0__fillcap_32_3/a_572_375# gf180mcu_fd_sc_mcu7t5v0__clkbuf_16_2/a_224_552# 0.02641f
C1212 gf180mcu_fd_sc_mcu7t5v0__fillcap_32_3/a_36_472# gf180mcu_fd_sc_mcu7t5v0__fillcap_32_0/a_36_472# 0
C1213 VDD gf180mcu_fd_sc_mcu7t5v0__dffq_1_2/a_448_472# 0.04939f
C1214 VDD gf180mcu_fd_sc_mcu7t5v0__fillcap_32_5/a_1020_375# 0.01007f
C1215 VDD gf180mcu_fd_sc_mcu7t5v0__dlyb_1_3/a_503_644# 0
C1216 gf180mcu_fd_sc_mcu7t5v0__dffq_1_0/a_448_472# gf180mcu_fd_sc_mcu7t5v0__xnor2_1_1/a_64_93# 0
C1217 count[1] gf180mcu_fd_sc_mcu7t5v0__dlyb_1_1/I 0.14781f
C1218 gf180mcu_fd_sc_mcu7t5v0__dlyb_1_3/I gf180mcu_fd_sc_mcu7t5v0__clkbuf_16_2/Z 0
C1219 gf180mcu_fd_sc_mcu7t5v0__fillcap_32_5/a_2812_375# gf180mcu_fd_sc_mcu7t5v0__clkbuf_16_2/Z 0.0052f
C1220 gf180mcu_fd_sc_mcu7t5v0__fillcap_4_3/a_36_472# count[1] 0.05641f
C1221 gf180mcu_fd_sc_mcu7t5v0__dlyb_1_1/I gf180mcu_fd_sc_mcu7t5v0__fillcap_4_7/a_124_375# 0.00401f
C1222 gf180mcu_fd_sc_mcu7t5v0__fillcap_4_5/a_124_375# gf180mcu_fd_sc_mcu7t5v0__dffq_1_0/a_2304_115# 0.00497f
C1223 clk gf180mcu_fd_sc_mcu7t5v0__fillcap_32_3/a_1916_375# 0.02961f
C1224 gf180mcu_fd_sc_mcu7t5v0__dffq_1_3/CLK gf180mcu_fd_sc_mcu7t5v0__dffq_1_3/a_36_151# 0.04718f
C1225 gf180mcu_fd_sc_mcu7t5v0__fillcap_32_0/a_484_472# gf180mcu_fd_sc_mcu7t5v0__fillcap_32_3/a_36_472# 0
C1226 gf180mcu_fd_sc_mcu7t5v0__dlyb_1_1/I gf180mcu_fd_sc_mcu7t5v0__fillcap_4_12/a_36_472# 0.06705f
C1227 gf180mcu_fd_sc_mcu7t5v0__fillcap_16_2/a_124_375# gf180mcu_fd_sc_mcu7t5v0__xnor2_1_1/A2 0.00521f
C1228 gf180mcu_fd_sc_mcu7t5v0__fillcap_8_1/a_484_472# gf180mcu_fd_sc_mcu7t5v0__dlyb_1_0/I 0.0019f
C1229 gf180mcu_fd_sc_mcu7t5v0__xnor2_1_1/a_64_93# gf180mcu_fd_sc_mcu7t5v0__clkbuf_16_2/Z 0
C1230 gf180mcu_fd_sc_mcu7t5v0__dffq_1_0/D gf180mcu_fd_sc_mcu7t5v0__fillcap_16_1/a_36_472# 0.00497f
C1231 VDD gf180mcu_fd_sc_mcu7t5v0__fillcap_32_6/a_932_472# -0
C1232 VDD gf180mcu_fd_sc_mcu7t5v0__fillcap_8_1/a_484_472# 0.00456f
C1233 gf180mcu_fd_sc_mcu7t5v0__dffq_1_2/D gf180mcu_fd_sc_mcu7t5v0__dffq_1_2/a_448_472# 0.01846f
C1234 gf180mcu_fd_sc_mcu7t5v0__fillcap_32_0/a_932_472# gf180mcu_fd_sc_mcu7t5v0__clkbuf_16_2/a_224_552# 0.00221f
C1235 gf180mcu_fd_sc_mcu7t5v0__fillcap_32_5/a_1020_375# gf180mcu_fd_sc_mcu7t5v0__dffq_1_2/D 0.0049f
C1236 gf180mcu_fd_sc_mcu7t5v0__clkbuf_16_1/a_224_552# gf180mcu_fd_sc_mcu7t5v0__fillcap_32_0/a_3260_375# 0
C1237 gf180mcu_fd_sc_mcu7t5v0__dlyb_1_1/I gf180mcu_fd_sc_mcu7t5v0__fillcap_4_6/a_36_472# 0.00156f
C1238 gf180mcu_fd_sc_mcu7t5v0__clkbuf_16_0/a_224_552# gf180mcu_fd_sc_mcu7t5v0__fillcap_32_4/a_124_375# 0.0264f
C1239 gf180mcu_fd_sc_mcu7t5v0__xnor2_1_0/a_716_68# gf180mcu_fd_sc_mcu7t5v0__dlyb_1_3/I 0
C1240 gf180mcu_fd_sc_mcu7t5v0__dlyb_1_0/a_671_644# gf180mcu_fd_sc_mcu7t5v0__fillcap_16_2/a_36_472# 0
C1241 gf180mcu_fd_sc_mcu7t5v0__fillcap_32_5/a_1468_375# gf180mcu_fd_sc_mcu7t5v0__clkbuf_16_2/Z 0.02029f
C1242 gf180mcu_fd_sc_mcu7t5v0__xor2_1_0/Z gf180mcu_fd_sc_mcu7t5v0__dffq_1_3/a_2304_115# 0.00463f
C1243 gf180mcu_fd_sc_mcu7t5v0__fillcap_32_1/a_1380_472# gf180mcu_fd_sc_mcu7t5v0__clkbuf_16_2/Z 0.00857f
C1244 gf180mcu_fd_sc_mcu7t5v0__dffq_1_2/D gf180mcu_fd_sc_mcu7t5v0__dffq_1_2/a_1348_527# 0
C1245 gf180mcu_fd_sc_mcu7t5v0__dffq_1_1/D gf180mcu_fd_sc_mcu7t5v0__dffq_1_3/a_36_151# 0.00331f
C1246 gf180mcu_fd_sc_mcu7t5v0__dlyb_1_2/a_895_68# gf180mcu_fd_sc_mcu7t5v0__fillcap_16_1/a_36_472# 0
C1247 gf180mcu_fd_sc_mcu7t5v0__dlyb_1_3/a_47_68# gf180mcu_fd_sc_mcu7t5v0__dffq_1_2/a_2011_527# 0
C1248 gf180mcu_fd_sc_mcu7t5v0__dffq_1_3/CLK gf180mcu_fd_sc_mcu7t5v0__fillcap_32_1/a_572_375# 0.00305f
C1249 clk gf180mcu_fd_sc_mcu7t5v0__fillcap_16_0/a_484_472# 0
C1250 gf180mcu_fd_sc_mcu7t5v0__dlyb_1_0/I gf180mcu_fd_sc_mcu7t5v0__dffq_1_3/a_2256_159# 0
C1251 VDD gf180mcu_fd_sc_mcu7t5v0__dffq_1_3/a_2256_159# 0
C1252 clk gf180mcu_fd_sc_mcu7t5v0__fillcap_32_0/a_2724_472# 0.00227f
C1253 gf180mcu_fd_sc_mcu7t5v0__dlyb_1_0/I gf180mcu_fd_sc_mcu7t5v0__dlyb_1_0/a_1147_68# 0
C1254 VDD gf180mcu_fd_sc_mcu7t5v0__dlyb_1_0/a_1147_68# 0
C1255 gf180mcu_fd_sc_mcu7t5v0__dlyb_1_1/I gf180mcu_fd_sc_mcu7t5v0__dffq_1_3/a_36_151# 0.00111f
C1256 gf180mcu_fd_sc_mcu7t5v0__clkbuf_16_0/a_224_552# gf180mcu_fd_sc_mcu7t5v0__dffq_1_2/a_2304_115# 0.00163f
C1257 gf180mcu_fd_sc_mcu7t5v0__xnor2_1_1/A2 gf180mcu_fd_sc_mcu7t5v0__dffq_1_2/a_448_472# 0.00129f
C1258 gf180mcu_fd_sc_mcu7t5v0__dffq_1_2/CLK gf180mcu_fd_sc_mcu7t5v0__fillcap_32_4/a_1468_375# 0.01161f
C1259 gf180mcu_fd_sc_mcu7t5v0__fillcap_32_0/a_124_375# gf180mcu_fd_sc_mcu7t5v0__xor2_1_0/Z 0
C1260 gf180mcu_fd_sc_mcu7t5v0__dffq_1_0/a_2296_527# gf180mcu_fd_sc_mcu7t5v0__dlyb_1_2/I 0
C1261 gf180mcu_fd_sc_mcu7t5v0__fillcap_4_2/a_36_472# gf180mcu_fd_sc_mcu7t5v0__fillcap_32_3/a_3172_472# 0.01328f
C1262 gf180mcu_fd_sc_mcu7t5v0__dlyb_1_2/a_895_68# gf180mcu_fd_sc_mcu7t5v0__dffq_1_0/a_2304_115# 0
C1263 gf180mcu_fd_sc_mcu7t5v0__dlyb_1_0/I gf180mcu_fd_sc_mcu7t5v0__dffq_1_3/a_2304_115# 0.10952f
C1264 count[1] gf180mcu_fd_sc_mcu7t5v0__xor2_1_0/Z 0
C1265 gf180mcu_fd_sc_mcu7t5v0__xor2_1_0/Z gf180mcu_fd_sc_mcu7t5v0__fillcap_16_2/a_932_472# 0.00282f
C1266 gf180mcu_fd_sc_mcu7t5v0__dffq_1_3/CLK gf180mcu_fd_sc_mcu7t5v0__clkbuf_16_2/Z 0.00452f
C1267 gf180mcu_fd_sc_mcu7t5v0__dffq_1_2/CLK gf180mcu_fd_sc_mcu7t5v0__fillcap_16_0/a_932_472# 0
C1268 VDD gf180mcu_fd_sc_mcu7t5v0__dffq_1_3/a_2304_115# 0.02845f
C1269 clk gf180mcu_fd_sc_mcu7t5v0__fillcap_32_3/a_3260_375# 0.03671f
C1270 clk gf180mcu_fd_sc_mcu7t5v0__clkbuf_16_2/a_224_552# 0.02726f
C1271 gf180mcu_fd_sc_mcu7t5v0__fillcap_32_0/a_572_375# gf180mcu_fd_sc_mcu7t5v0__dffq_1_3/a_36_151# 0
C1272 gf180mcu_fd_sc_mcu7t5v0__fillcap_32_0/a_1828_472# gf180mcu_fd_sc_mcu7t5v0__clkbuf_16_2/a_224_552# 0
C1273 gf180mcu_fd_sc_mcu7t5v0__dffq_1_0/a_36_151# gf180mcu_fd_sc_mcu7t5v0__dffq_1_0/a_448_472# 0
C1274 gf180mcu_fd_sc_mcu7t5v0__dffq_1_0/a_448_472# gf180mcu_fd_sc_mcu7t5v0__dlyb_1_2/I 0.00256f
C1275 gf180mcu_fd_sc_mcu7t5v0__dffq_1_2/CLK gf180mcu_fd_sc_mcu7t5v0__fillcap_32_6/a_36_472# 0
C1276 gf180mcu_fd_sc_mcu7t5v0__dffq_1_3/a_448_472# gf180mcu_fd_sc_mcu7t5v0__fillcap_16_2/a_932_472# 0.00179f
C1277 count[1] gf180mcu_fd_sc_mcu7t5v0__dffq_1_3/a_448_472# 0
C1278 gf180mcu_fd_sc_mcu7t5v0__nand3_1_0/a_455_68# gf180mcu_fd_sc_mcu7t5v0__fillcap_4_6/a_124_375# 0
C1279 gf180mcu_fd_sc_mcu7t5v0__dffq_1_0/a_2304_115# gf180mcu_fd_sc_mcu7t5v0__xnor2_1_0/A2 0.01726f
C1280 VDD gf180mcu_fd_sc_mcu7t5v0__xnor2_1_0/a_64_93# 0.01063f
C1281 gf180mcu_fd_sc_mcu7t5v0__clkbuf_16_0/a_224_552# gf180mcu_fd_sc_mcu7t5v0__dffq_1_2/CLK 0.07566f
C1282 gf180mcu_fd_sc_mcu7t5v0__dlyb_1_1/a_671_644# gf180mcu_fd_sc_mcu7t5v0__dffq_1_1/a_2304_115# 0
C1283 gf180mcu_fd_sc_mcu7t5v0__dlyb_1_1/a_47_68# gf180mcu_fd_sc_mcu7t5v0__xor2_1_0/a_56_604# 0.01642f
C1284 gf180mcu_fd_sc_mcu7t5v0__xnor2_1_0/a_64_93# gf180mcu_fd_sc_mcu7t5v0__dffq_1_0/a_2011_527# 0
C1285 gf180mcu_fd_sc_mcu7t5v0__fillcap_32_0/a_124_375# gf180mcu_fd_sc_mcu7t5v0__fillcap_32_1/a_36_472# 0.00168f
C1286 gf180mcu_fd_sc_mcu7t5v0__fillcap_4_9/a_124_375# gf180mcu_fd_sc_mcu7t5v0__clkbuf_16_2/Z 0.00273f
C1287 gf180mcu_fd_sc_mcu7t5v0__fillcap_32_0/a_1020_375# gf180mcu_fd_sc_mcu7t5v0__dffq_1_3/CLK 0.00197f
C1288 VDD gf180mcu_fd_sc_mcu7t5v0__fillcap_32_0/a_1916_375# 0.02393f
C1289 gf180mcu_fd_sc_mcu7t5v0__fillcap_32_3/a_2276_472# gf180mcu_fd_sc_mcu7t5v0__fillcap_32_0/a_2364_375# 0.00154f
C1290 gf180mcu_fd_sc_mcu7t5v0__fillcap_32_0/a_932_472# gf180mcu_fd_sc_mcu7t5v0__fillcap_32_3/a_932_472# 0
C1291 gf180mcu_fd_sc_mcu7t5v0__dlyb_1_2/a_1127_622# gf180mcu_fd_sc_mcu7t5v0__dlyb_1_2/I 0
C1292 gf180mcu_fd_sc_mcu7t5v0__fillcap_32_0/a_572_375# gf180mcu_fd_sc_mcu7t5v0__fillcap_32_1/a_572_375# 0
C1293 VDD gf180mcu_fd_sc_mcu7t5v0__fillcap_32_0/a_124_375# 0.02843f
C1294 gf180mcu_fd_sc_mcu7t5v0__xnor2_1_0/a_716_68# gf180mcu_fd_sc_mcu7t5v0__dffq_1_0/a_36_151# 0
C1295 gf180mcu_fd_sc_mcu7t5v0__dlyb_1_3/a_671_644# gf180mcu_fd_sc_mcu7t5v0__xnor2_1_0/A2 0.01769f
C1296 gf180mcu_fd_sc_mcu7t5v0__xnor2_1_0/a_716_68# gf180mcu_fd_sc_mcu7t5v0__dlyb_1_2/I 0.02055f
C1297 gf180mcu_fd_sc_mcu7t5v0__fillcap_16_2/a_484_472# gf180mcu_fd_sc_mcu7t5v0__clkbuf_16_2/a_224_552# 0
C1298 gf180mcu_fd_sc_mcu7t5v0__clkbuf_16_2/a_224_552# gf180mcu_fd_sc_mcu7t5v0__fillcap_32_5/a_484_472# 0.01432f
C1299 gf180mcu_fd_sc_mcu7t5v0__fillcap_32_1/a_2724_472# gf180mcu_fd_sc_mcu7t5v0__clkbuf_16_2/Z 0.0189f
C1300 gf180mcu_fd_sc_mcu7t5v0__dlyb_1_0/I gf180mcu_fd_sc_mcu7t5v0__fillcap_16_2/a_932_472# 0.00118f
C1301 count[1] gf180mcu_fd_sc_mcu7t5v0__dlyb_1_0/I 0
C1302 gf180mcu_fd_sc_mcu7t5v0__dlyb_1_1/I gf180mcu_fd_sc_mcu7t5v0__clkbuf_16_2/Z 0.00151f
C1303 VDD count[1] 0.26359f
C1304 VDD gf180mcu_fd_sc_mcu7t5v0__fillcap_16_2/a_932_472# 0.03563f
C1305 gf180mcu_fd_sc_mcu7t5v0__clkbuf_16_0/a_224_552# gf180mcu_fd_sc_mcu7t5v0__fillcap_16_1/a_572_375# 0
C1306 gf180mcu_fd_sc_mcu7t5v0__dlyb_1_0/I gf180mcu_fd_sc_mcu7t5v0__fillcap_4_7/a_124_375# 0.0158f
C1307 gf180mcu_fd_sc_mcu7t5v0__xnor2_1_0/A2 gf180mcu_fd_sc_mcu7t5v0__dffq_1_2/a_2011_527# 0
C1308 gf180mcu_fd_sc_mcu7t5v0__fillcap_32_2/a_2812_375# gf180mcu_fd_sc_mcu7t5v0__clkbuf_16_1/a_224_552# 0
C1309 gf180mcu_fd_sc_mcu7t5v0__xor2_1_0/Z gf180mcu_fd_sc_mcu7t5v0__dffq_1_3/a_36_151# 0.03074f
C1310 gf180mcu_fd_sc_mcu7t5v0__fillcap_32_0/a_2364_375# gf180mcu_fd_sc_mcu7t5v0__clkbuf_16_2/Z 0.02484f
C1311 gf180mcu_fd_sc_mcu7t5v0__dlyb_1_0/I gf180mcu_fd_sc_mcu7t5v0__fillcap_4_12/a_36_472# 0.01301f
C1312 VDD gf180mcu_fd_sc_mcu7t5v0__fillcap_4_7/a_124_375# 0.03224f
C1313 VDD gf180mcu_fd_sc_mcu7t5v0__fillcap_4_12/a_36_472# 0.08782f
C1314 gf180mcu_fd_sc_mcu7t5v0__fillcap_4_7/a_36_472# gf180mcu_fd_sc_mcu7t5v0__dffq_1_0/a_1004_159# 0
C1315 gf180mcu_fd_sc_mcu7t5v0__dlyb_1_0/I gf180mcu_fd_sc_mcu7t5v0__fillcap_4_6/a_36_472# 0
C1316 VDD gf180mcu_fd_sc_mcu7t5v0__fillcap_4_6/a_36_472# 0.10412f
C1317 gf180mcu_fd_sc_mcu7t5v0__dffq_1_0/a_2304_115# gf180mcu_fd_sc_mcu7t5v0__dlyb_1_3/I 0.00614f
C1318 gf180mcu_fd_sc_mcu7t5v0__fillcap_32_0/a_572_375# gf180mcu_fd_sc_mcu7t5v0__clkbuf_16_2/Z 0.00119f
C1319 gf180mcu_fd_sc_mcu7t5v0__fillcap_16_1/a_1380_472# gf180mcu_fd_sc_mcu7t5v0__fillcap_32_6/a_36_472# 0.00347f
C1320 gf180mcu_fd_sc_mcu7t5v0__dffq_1_1/a_448_472# gf180mcu_fd_sc_mcu7t5v0__fillcap_16_2/a_484_472# 0
C1321 gf180mcu_fd_sc_mcu7t5v0__clkbuf_16_0/a_224_552# gf180mcu_fd_sc_mcu7t5v0__fillcap_32_4/a_2364_375# 0.00137f
C1322 VDD gf180mcu_fd_sc_mcu7t5v0__fillcap_4_10/a_36_472# 0.09454f
C1323 gf180mcu_fd_sc_mcu7t5v0__dffq_1_3/a_36_151# gf180mcu_fd_sc_mcu7t5v0__dffq_1_3/a_448_472# 0
C1324 gf180mcu_fd_sc_mcu7t5v0__dffq_1_1/a_1004_159# gf180mcu_fd_sc_mcu7t5v0__fillcap_16_2/a_484_472# 0
C1325 gf180mcu_fd_sc_mcu7t5v0__clkbuf_16_0/a_224_552# gf180mcu_fd_sc_mcu7t5v0__fillcap_16_1/a_1380_472# 0.01591f
C1326 gf180mcu_fd_sc_mcu7t5v0__fillcap_32_3/a_1468_375# gf180mcu_fd_sc_mcu7t5v0__clkbuf_16_2/a_224_552# 0.02641f
C1327 gf180mcu_fd_sc_mcu7t5v0__dffq_1_2/D gf180mcu_fd_sc_mcu7t5v0__fillcap_4_7/a_124_375# 0
C1328 gf180mcu_fd_sc_mcu7t5v0__dlyb_1_3/a_895_68# count[2] 0.02325f
C1329 VDD gf180mcu_fd_sc_mcu7t5v0__fillcap_32_1/a_1828_472# 0.00284f
C1330 gf180mcu_fd_sc_mcu7t5v0__dlyb_1_3/a_671_644# gf180mcu_fd_sc_mcu7t5v0__dlyb_1_3/I 0.08862f
C1331 gf180mcu_fd_sc_mcu7t5v0__dlyb_1_1/I gf180mcu_fd_sc_mcu7t5v0__xor2_1_0/a_952_68# 0
C1332 clk gf180mcu_fd_sc_mcu7t5v0__fillcap_32_3/a_2812_375# 0.03887f
C1333 gf180mcu_fd_sc_mcu7t5v0__dffq_1_3/CLK gf180mcu_fd_sc_mcu7t5v0__dffq_1_3/a_1376_115# 0
C1334 gf180mcu_fd_sc_mcu7t5v0__fillcap_32_0/a_932_472# gf180mcu_fd_sc_mcu7t5v0__fillcap_32_3/a_484_472# 0
C1335 gf180mcu_fd_sc_mcu7t5v0__dlyb_1_3/I gf180mcu_fd_sc_mcu7t5v0__dffq_1_2/a_2011_527# 0.00955f
C1336 gf180mcu_fd_sc_mcu7t5v0__fillcap_32_6/a_3172_472# gf180mcu_fd_sc_mcu7t5v0__fillcap_4_11/a_36_472# 0.00347f
C1337 gf180mcu_fd_sc_mcu7t5v0__fillcap_4_13/a_36_472# gf180mcu_fd_sc_mcu7t5v0__fillcap_8_0/a_572_375# 0.08663f
C1338 gf180mcu_fd_sc_mcu7t5v0__dlyb_1_0/I gf180mcu_fd_sc_mcu7t5v0__dffq_1_3/a_36_151# 0.01426f
C1339 VDD gf180mcu_fd_sc_mcu7t5v0__fillcap_4_1/a_36_472# 0.11033f
C1340 VDD gf180mcu_fd_sc_mcu7t5v0__dffq_1_3/a_36_151# 0.03758f
C1341 gf180mcu_fd_sc_mcu7t5v0__dffq_1_2/a_2011_527# gf180mcu_fd_sc_mcu7t5v0__xnor2_1_1/a_64_93# 0.01069f
C1342 gf180mcu_fd_sc_mcu7t5v0__dlyb_1_1/a_1147_68# count[0] 0
C1343 gf180mcu_fd_sc_mcu7t5v0__fillcap_32_1/a_2276_472# gf180mcu_fd_sc_mcu7t5v0__clkbuf_16_2/Z 0.03144f
C1344 count[3] gf180mcu_fd_sc_mcu7t5v0__dffq_1_0/a_2304_115# 0
C1345 gf180mcu_fd_sc_mcu7t5v0__dffq_1_3/CLK gf180mcu_fd_sc_mcu7t5v0__fillcap_32_1/a_484_472# 0.0042f
C1346 gf180mcu_fd_sc_mcu7t5v0__fillcap_16_1/a_124_375# gf180mcu_fd_sc_mcu7t5v0__dffq_1_0/a_448_472# 0
C1347 gf180mcu_fd_sc_mcu7t5v0__dffq_1_1/D gf180mcu_fd_sc_mcu7t5v0__dffq_1_3/a_1376_115# 0.00311f
C1348 gf180mcu_fd_sc_mcu7t5v0__xor2_1_0/Z gf180mcu_fd_sc_mcu7t5v0__clkbuf_16_2/Z 0.00221f
C1349 gf180mcu_fd_sc_mcu7t5v0__clkbuf_16_1/a_224_552# gf180mcu_fd_sc_mcu7t5v0__fillcap_32_0/a_932_472# 0
C1350 gf180mcu_fd_sc_mcu7t5v0__fillcap_4_0/a_124_375# gf180mcu_fd_sc_mcu7t5v0__fillcap_4_1/a_124_375# 0
C1351 gf180mcu_fd_sc_mcu7t5v0__fillcap_32_3/a_1916_375# gf180mcu_fd_sc_mcu7t5v0__clkbuf_16_2/a_224_552# 0.00137f
C1352 gf180mcu_fd_sc_mcu7t5v0__xnor2_1_1/A2 gf180mcu_fd_sc_mcu7t5v0__fillcap_4_7/a_124_375# 0.01108f
C1353 gf180mcu_fd_sc_mcu7t5v0__fillcap_4_3/a_124_375# gf180mcu_fd_sc_mcu7t5v0__dlyb_1_1/I 0.03359f
C1354 gf180mcu_fd_sc_mcu7t5v0__xnor2_1_1/A2 gf180mcu_fd_sc_mcu7t5v0__fillcap_4_12/a_36_472# 0.00352f
C1355 gf180mcu_fd_sc_mcu7t5v0__dlyb_1_3/a_895_68# gf180mcu_fd_sc_mcu7t5v0__fillcap_8_1/a_484_472# 0
C1356 gf180mcu_fd_sc_mcu7t5v0__dffq_1_0/a_36_151# gf180mcu_fd_sc_mcu7t5v0__fillcap_16_1/a_36_472# 0.00279f
C1357 gf180mcu_fd_sc_mcu7t5v0__clkbuf_16_0/a_224_552# gf180mcu_fd_sc_mcu7t5v0__fillcap_32_4/a_932_472# 0.001f
C1358 gf180mcu_fd_sc_mcu7t5v0__dlyb_1_2/I gf180mcu_fd_sc_mcu7t5v0__fillcap_16_1/a_36_472# 0.01197f
C1359 gf180mcu_fd_sc_mcu7t5v0__dffq_1_0/a_880_527# gf180mcu_fd_sc_mcu7t5v0__dffq_1_0/D 0.00114f
C1360 gf180mcu_fd_sc_mcu7t5v0__fillcap_32_2/a_36_472# gf180mcu_fd_sc_mcu7t5v0__fillcap_4_13/a_124_375# 0.01675f
C1361 VDD gf180mcu_fd_sc_mcu7t5v0__fillcap_32_1/a_572_375# 0.02153f
C1362 VDD gf180mcu_fd_sc_mcu7t5v0__fillcap_32_3/a_2276_472# 0.01856f
C1363 gf180mcu_fd_sc_mcu7t5v0__dlyb_1_0/a_895_68# gf180mcu_fd_sc_mcu7t5v0__dlyb_1_1/I 0.08169f
C1364 gf180mcu_fd_sc_mcu7t5v0__clkbuf_16_0/a_224_552# gf180mcu_fd_sc_mcu7t5v0__fillcap_16_0/a_124_375# 0
C1365 gf180mcu_fd_sc_mcu7t5v0__dlyb_1_1/I gf180mcu_fd_sc_mcu7t5v0__dffq_1_3/a_1376_115# 0
C1366 gf180mcu_fd_sc_mcu7t5v0__fillcap_4_3/a_36_472# gf180mcu_fd_sc_mcu7t5v0__dlyb_1_0/a_895_68# 0.03525f
C1367 VDD gf180mcu_fd_sc_mcu7t5v0__fillcap_32_3/a_124_375# 0.02533f
C1368 VDD gf180mcu_fd_sc_mcu7t5v0__dffq_1_0/a_1004_159# 0.00873f
C1369 gf180mcu_fd_sc_mcu7t5v0__clkbuf_16_0/a_224_552# gf180mcu_fd_sc_mcu7t5v0__fillcap_32_6/a_1020_375# 0
C1370 gf180mcu_fd_sc_mcu7t5v0__dlyb_1_1/I count[0] 0.01597f
C1371 gf180mcu_fd_sc_mcu7t5v0__dlyb_1_0/I gf180mcu_fd_sc_mcu7t5v0__dffq_1_0/a_448_472# 0
C1372 gf180mcu_fd_sc_mcu7t5v0__dffq_1_2/CLK gf180mcu_fd_sc_mcu7t5v0__fillcap_32_4/a_484_472# 0.01225f
C1373 VDD gf180mcu_fd_sc_mcu7t5v0__dffq_1_0/a_448_472# 0.02124f
C1374 gf180mcu_fd_sc_mcu7t5v0__dffq_1_2/CLK gf180mcu_fd_sc_mcu7t5v0__dffq_1_2/a_448_472# 0.01496f
C1375 gf180mcu_fd_sc_mcu7t5v0__fillcap_32_5/a_1020_375# gf180mcu_fd_sc_mcu7t5v0__dffq_1_2/CLK 0.01311f
C1376 VDD gf180mcu_fd_sc_mcu7t5v0__fillcap_4_9/a_36_472# 0.08961f
C1377 gf180mcu_fd_sc_mcu7t5v0__dffq_1_3/CLK gf180mcu_fd_sc_mcu7t5v0__dffq_1_1/a_836_159# 0
C1378 gf180mcu_fd_sc_mcu7t5v0__xor2_1_0/Z gf180mcu_fd_sc_mcu7t5v0__xor2_1_0/a_952_68# 0.00134f
C1379 gf180mcu_fd_sc_mcu7t5v0__dffq_1_0/a_2304_115# gf180mcu_fd_sc_mcu7t5v0__dlyb_1_2/I 0.01693f
C1380 gf180mcu_fd_sc_mcu7t5v0__fillcap_32_3/a_124_375# gf180mcu_fd_sc_mcu7t5v0__dffq_1_2/D 0.0017f
C1381 gf180mcu_fd_sc_mcu7t5v0__fillcap_32_0/a_3172_472# gf180mcu_fd_sc_mcu7t5v0__clkbuf_16_2/Z 0.00351f
C1382 gf180mcu_fd_sc_mcu7t5v0__dlyb_1_0/I gf180mcu_fd_sc_mcu7t5v0__clkbuf_16_2/Z 0.00456f
C1383 gf180mcu_fd_sc_mcu7t5v0__fillcap_32_0/a_2724_472# gf180mcu_fd_sc_mcu7t5v0__clkbuf_16_2/a_224_552# 0
C1384 gf180mcu_fd_sc_mcu7t5v0__dffq_1_1/a_2011_527# gf180mcu_fd_sc_mcu7t5v0__dffq_1_3/a_2304_115# 0.0015f
C1385 gf180mcu_fd_sc_mcu7t5v0__fillcap_32_3/a_2724_472# gf180mcu_fd_sc_mcu7t5v0__clkbuf_16_2/Z 0.0053f
C1386 VDD gf180mcu_fd_sc_mcu7t5v0__clkbuf_16_2/Z 0.99751f
C1387 gf180mcu_fd_sc_mcu7t5v0__dffq_1_2/CLK gf180mcu_fd_sc_mcu7t5v0__fillcap_32_6/a_932_472# 0.00175f
C1388 gf180mcu_fd_sc_mcu7t5v0__xnor2_1_1/A2 gf180mcu_fd_sc_mcu7t5v0__dffq_1_3/a_36_151# 0
C1389 VDD gf180mcu_fd_sc_mcu7t5v0__fillcap_32_1/a_3172_472# 0.00299f
C1390 gf180mcu_fd_sc_mcu7t5v0__clkbuf_16_0/a_224_552# gf180mcu_fd_sc_mcu7t5v0__fillcap_32_6/a_3172_472# 0
C1391 gf180mcu_fd_sc_mcu7t5v0__dlyb_1_1/a_671_644# gf180mcu_fd_sc_mcu7t5v0__xor2_1_0/a_56_604# 0.00253f
C1392 gf180mcu_fd_sc_mcu7t5v0__dffq_1_1/D gf180mcu_fd_sc_mcu7t5v0__dffq_1_1/a_836_159# 0
C1393 gf180mcu_fd_sc_mcu7t5v0__dlyb_1_3/a_671_644# gf180mcu_fd_sc_mcu7t5v0__dlyb_1_2/I 0.00187f
C1394 gf180mcu_fd_sc_mcu7t5v0__fillcap_32_0/a_572_375# gf180mcu_fd_sc_mcu7t5v0__fillcap_32_1/a_484_472# 0.00168f
C1395 gf180mcu_fd_sc_mcu7t5v0__dffq_1_3/a_2011_527# gf180mcu_fd_sc_mcu7t5v0__fillcap_4_12/a_124_375# 0.00109f
C1396 gf180mcu_fd_sc_mcu7t5v0__fillcap_16_2/a_1380_472# gf180mcu_fd_sc_mcu7t5v0__clkbuf_16_2/a_224_552# 0
C1397 clk gf180mcu_fd_sc_mcu7t5v0__fillcap_32_5/a_1916_375# 0.00116f
C1398 VDD gf180mcu_fd_sc_mcu7t5v0__xnor2_1_0/a_716_68# 0.00113f
C1399 gf180mcu_fd_sc_mcu7t5v0__clkbuf_16_1/a_224_552# gf180mcu_fd_sc_mcu7t5v0__fillcap_32_0/a_1828_472# 0
C1400 gf180mcu_fd_sc_mcu7t5v0__fillcap_32_3/a_3260_375# gf180mcu_fd_sc_mcu7t5v0__clkbuf_16_2/a_224_552# 0.00129f
C1401 gf180mcu_fd_sc_mcu7t5v0__dffq_1_2/D gf180mcu_fd_sc_mcu7t5v0__clkbuf_16_2/Z 0.01483f
C1402 gf180mcu_fd_sc_mcu7t5v0__dlyb_1_1/a_47_68# gf180mcu_fd_sc_mcu7t5v0__dffq_1_1/a_448_472# 0
C1403 gf180mcu_fd_sc_mcu7t5v0__dlyb_1_2/a_1147_68# gf180mcu_fd_sc_mcu7t5v0__dlyb_1_2/I 0
C1404 gf180mcu_fd_sc_mcu7t5v0__fillcap_32_0/a_1380_472# gf180mcu_fd_sc_mcu7t5v0__fillcap_32_3/a_1380_472# 0
C1405 gf180mcu_fd_sc_mcu7t5v0__dlyb_1_3/a_523_68# gf180mcu_fd_sc_mcu7t5v0__xnor2_1_0/A2 0
C1406 gf180mcu_fd_sc_mcu7t5v0__dffq_1_0/a_36_151# gf180mcu_fd_sc_mcu7t5v0__dffq_1_2/a_2011_527# 0.00838f
C1407 gf180mcu_fd_sc_mcu7t5v0__fillcap_4_3/a_124_375# gf180mcu_fd_sc_mcu7t5v0__xor2_1_0/Z 0
C1408 VDD gf180mcu_fd_sc_mcu7t5v0__fillcap_32_0/a_1020_375# 0.02336f
C1409 gf180mcu_fd_sc_mcu7t5v0__fillcap_4_8/a_124_375# gf180mcu_fd_sc_mcu7t5v0__fillcap_4_10/a_36_472# 0.0027f
C1410 gf180mcu_fd_sc_mcu7t5v0__fillcap_16_1/a_1468_375# gf180mcu_fd_sc_mcu7t5v0__fillcap_32_6/a_36_472# 0.01675f
C1411 gf180mcu_fd_sc_mcu7t5v0__dlyb_1_3/a_671_644# gf180mcu_fd_sc_mcu7t5v0__dlyb_1_1/I 0.00636f
C1412 VDD gf180mcu_fd_sc_mcu7t5v0__fillcap_32_5/a_932_472# -0
C1413 clk gf180mcu_fd_sc_mcu7t5v0__fillcap_16_0/a_1380_472# 0
C1414 gf180mcu_fd_sc_mcu7t5v0__dlyb_1_0/I gf180mcu_fd_sc_mcu7t5v0__xor2_1_0/a_952_68# 0
C1415 gf180mcu_fd_sc_mcu7t5v0__clkbuf_16_0/a_224_552# gf180mcu_fd_sc_mcu7t5v0__fillcap_16_1/a_1468_375# 0
C1416 VDD gf180mcu_fd_sc_mcu7t5v0__xor2_1_0/a_952_68# 0
C1417 gf180mcu_fd_sc_mcu7t5v0__fillcap_32_0/a_2812_375# gf180mcu_fd_sc_mcu7t5v0__clkbuf_16_2/Z 0.01021f
C1418 gf180mcu_fd_sc_mcu7t5v0__xor2_1_0/Z gf180mcu_fd_sc_mcu7t5v0__dffq_1_3/a_1376_115# 0.02747f
C1419 gf180mcu_fd_sc_mcu7t5v0__fillcap_8_1/a_124_375# gf180mcu_fd_sc_mcu7t5v0__dlyb_1_1/I 0.03018f
C1420 gf180mcu_fd_sc_mcu7t5v0__xnor2_1_1/A2 gf180mcu_fd_sc_mcu7t5v0__dffq_1_0/a_1004_159# 0
C1421 gf180mcu_fd_sc_mcu7t5v0__fillcap_4_3/a_36_472# gf180mcu_fd_sc_mcu7t5v0__fillcap_8_1/a_124_375# 0.00108f
C1422 gf180mcu_fd_sc_mcu7t5v0__clkbuf_16_0/a_224_552# gf180mcu_fd_sc_mcu7t5v0__fillcap_16_0/a_36_472# 0
C1423 gf180mcu_fd_sc_mcu7t5v0__xnor2_1_1/A2 gf180mcu_fd_sc_mcu7t5v0__dffq_1_0/a_448_472# 0
C1424 gf180mcu_fd_sc_mcu7t5v0__fillcap_32_2/a_932_472# gf180mcu_fd_sc_mcu7t5v0__clkbuf_16_1/a_224_552# 0
C1425 gf180mcu_fd_sc_mcu7t5v0__clkbuf_16_1/a_224_552# gf180mcu_fd_sc_mcu7t5v0__fillcap_4_13/a_36_472# 0
C1426 gf180mcu_fd_sc_mcu7t5v0__xor2_1_0/a_56_604# gf180mcu_fd_sc_mcu7t5v0__clkbuf_16_1/a_224_552# 0
C1427 gf180mcu_fd_sc_mcu7t5v0__dffq_1_2/D gf180mcu_fd_sc_mcu7t5v0__fillcap_32_5/a_932_472# 0.00269f
C1428 gf180mcu_fd_sc_mcu7t5v0__dlyb_1_3/a_1147_68# count[2] 0
C1429 gf180mcu_fd_sc_mcu7t5v0__fillcap_32_5/a_1380_472# gf180mcu_fd_sc_mcu7t5v0__clkbuf_16_2/Z 0.01715f
C1430 gf180mcu_fd_sc_mcu7t5v0__xnor2_1_1/A2 gf180mcu_fd_sc_mcu7t5v0__clkbuf_16_2/Z 0.03423f
C1431 gf180mcu_fd_sc_mcu7t5v0__fillcap_32_2/a_124_375# gf180mcu_fd_sc_mcu7t5v0__fillcap_4_13/a_124_375# 0.00544f
C1432 gf180mcu_fd_sc_mcu7t5v0__dffq_1_2/a_448_472# gf180mcu_fd_sc_mcu7t5v0__fillcap_32_5/a_36_472# 0
C1433 gf180mcu_fd_sc_mcu7t5v0__dlyb_1_3/a_523_68# gf180mcu_fd_sc_mcu7t5v0__dlyb_1_3/I 0
C1434 gf180mcu_fd_sc_mcu7t5v0__fillcap_4_3/a_124_375# gf180mcu_fd_sc_mcu7t5v0__dlyb_1_0/I 0.11811f
C1435 gf180mcu_fd_sc_mcu7t5v0__dlyb_1_3/a_1127_622# gf180mcu_fd_sc_mcu7t5v0__dlyb_1_3/I 0
C1436 VDD gf180mcu_fd_sc_mcu7t5v0__fillcap_4_3/a_124_375# 0.03404f
C1437 gf180mcu_fd_sc_mcu7t5v0__xnor2_1_0/a_64_93# gf180mcu_fd_sc_mcu7t5v0__dffq_1_2/CLK 0
C1438 gf180mcu_fd_sc_mcu7t5v0__fillcap_32_5/a_1916_375# gf180mcu_fd_sc_mcu7t5v0__fillcap_16_0/a_572_375# 0.05841f
C1439 gf180mcu_fd_sc_mcu7t5v0__dlyb_1_0/a_895_68# gf180mcu_fd_sc_mcu7t5v0__dlyb_1_0/I 0.01099f
C1440 clk gf180mcu_fd_sc_mcu7t5v0__fillcap_32_3/a_1828_472# 0
C1441 gf180mcu_fd_sc_mcu7t5v0__fillcap_4_13/a_36_472# gf180mcu_fd_sc_mcu7t5v0__fillcap_8_0/a_484_472# 0.01328f
C1442 gf180mcu_fd_sc_mcu7t5v0__dlyb_1_0/I gf180mcu_fd_sc_mcu7t5v0__dffq_1_3/a_1376_115# 0.0034f
C1443 VDD gf180mcu_fd_sc_mcu7t5v0__dlyb_1_0/a_895_68# 0.02758f
C1444 gf180mcu_fd_sc_mcu7t5v0__fillcap_32_0/a_1828_472# gf180mcu_fd_sc_mcu7t5v0__fillcap_32_3/a_1828_472# 0
C1445 VDD gf180mcu_fd_sc_mcu7t5v0__fillcap_32_5/a_2276_472# -0
C1446 gf180mcu_fd_sc_mcu7t5v0__fillcap_32_5/a_1020_375# gf180mcu_fd_sc_mcu7t5v0__fillcap_32_4/a_932_472# 0.00108f
C1447 gf180mcu_fd_sc_mcu7t5v0__dlyb_1_1/I gf180mcu_fd_sc_mcu7t5v0__fillcap_4_4/a_36_472# 0.01282f
C1448 VDD gf180mcu_fd_sc_mcu7t5v0__dffq_1_3/a_1376_115# 0.01415f
C1449 VDD count[0] 0.11715f
C1450 clk gf180mcu_fd_sc_mcu7t5v0__fillcap_4_2/a_36_472# 0.00546f
C1451 VDD gf180mcu_fd_sc_mcu7t5v0__fillcap_16_1/a_36_472# 0.01348f
C1452 gf180mcu_fd_sc_mcu7t5v0__dffq_1_1/a_2011_527# gf180mcu_fd_sc_mcu7t5v0__dffq_1_3/a_36_151# 0
C1453 gf180mcu_fd_sc_mcu7t5v0__fillcap_4_6/a_124_375# gf180mcu_fd_sc_mcu7t5v0__xnor2_1_0/A2 0.03093f
C1454 gf180mcu_fd_sc_mcu7t5v0__dffq_1_2/a_36_151# gf180mcu_fd_sc_mcu7t5v0__fillcap_16_0/a_572_375# 0
C1455 gf180mcu_fd_sc_mcu7t5v0__xor2_1_0/Z gf180mcu_fd_sc_mcu7t5v0__dffq_1_1/a_836_159# 0
C1456 gf180mcu_fd_sc_mcu7t5v0__fillcap_32_3/a_2812_375# gf180mcu_fd_sc_mcu7t5v0__clkbuf_16_2/a_224_552# 0.00137f
C1457 VDD gf180mcu_fd_sc_mcu7t5v0__fillcap_32_1/a_484_472# 0.00336f
C1458 gf180mcu_fd_sc_mcu7t5v0__fillcap_32_3/a_932_472# gf180mcu_fd_sc_mcu7t5v0__clkbuf_16_2/a_224_552# 0.001f
C1459 gf180mcu_fd_sc_mcu7t5v0__dlyb_1_2/I gf180mcu_fd_sc_mcu7t5v0__fillcap_16_1/a_932_472# 0
C1460 gf180mcu_fd_sc_mcu7t5v0__clkbuf_16_0/a_224_552# gf180mcu_fd_sc_mcu7t5v0__fillcap_32_4/a_572_375# 0.02641f
C1461 gf180mcu_fd_sc_mcu7t5v0__fillcap_32_6/a_3260_375# gf180mcu_fd_sc_mcu7t5v0__fillcap_4_11/a_36_472# 0.01675f
C1462 gf180mcu_fd_sc_mcu7t5v0__dffq_1_3/CLK gf180mcu_fd_sc_mcu7t5v0__fillcap_16_2/a_1468_375# 0.00212f
C1463 gf180mcu_fd_sc_mcu7t5v0__fillcap_32_5/a_2724_472# gf180mcu_fd_sc_mcu7t5v0__clkbuf_16_2/Z 0.0053f
C1464 VDD gf180mcu_fd_sc_mcu7t5v0__fillcap_32_2/a_1916_375# 0.00126f
C1465 gf180mcu_fd_sc_mcu7t5v0__fillcap_32_0/a_3172_472# gf180mcu_fd_sc_mcu7t5v0__fillcap_32_3/a_3172_472# 0
C1466 VDD gf180mcu_fd_sc_mcu7t5v0__fillcap_32_3/a_3172_472# 0.01818f
C1467 gf180mcu_fd_sc_mcu7t5v0__dlyb_1_1/I gf180mcu_fd_sc_mcu7t5v0__dffq_1_3/a_2011_527# 0.00553f
C1468 VDD gf180mcu_fd_sc_mcu7t5v0__dffq_1_0/a_2304_115# 0.02593f
C1469 gf180mcu_fd_sc_mcu7t5v0__dffq_1_2/a_448_472# gf180mcu_fd_sc_mcu7t5v0__fillcap_32_5/a_124_375# 0
C1470 gf180mcu_fd_sc_mcu7t5v0__fillcap_4_3/a_36_472# gf180mcu_fd_sc_mcu7t5v0__dffq_1_3/a_2011_527# 0
C1471 gf180mcu_fd_sc_mcu7t5v0__dffq_1_3/a_36_151# gf180mcu_fd_sc_mcu7t5v0__fillcap_32_0/a_36_472# 0.08674f
C1472 gf180mcu_fd_sc_mcu7t5v0__fillcap_32_1/a_932_472# gf180mcu_fd_sc_mcu7t5v0__clkbuf_16_2/Z 0.0036f
C1473 VDD gf180mcu_fd_sc_mcu7t5v0__fillcap_4_0/a_36_472# 0.0986f
C1474 gf180mcu_fd_sc_mcu7t5v0__fillcap_8_1/a_572_375# gf180mcu_fd_sc_mcu7t5v0__dlyb_1_0/a_671_644# 0.02503f
C1475 gf180mcu_fd_sc_mcu7t5v0__clkbuf_16_0/a_224_552# gf180mcu_fd_sc_mcu7t5v0__fillcap_32_6/a_572_375# 0
C1476 count[0] VSS 0.96518f
C1477 count[1] VSS 0.65349f
C1478 count[2] VSS 0.46263f
C1479 count[3] VSS 0.82451f
C1480 gf180mcu_fd_sc_mcu7t5v0__dffq_1_3/CLK VSS 0.12606f
C1481 gf180mcu_fd_sc_mcu7t5v0__dlyb_1_1/I VSS -0.32374f
C1482 gf180mcu_fd_sc_mcu7t5v0__dffq_1_1/D VSS 0.01369f
C1483 gf180mcu_fd_sc_mcu7t5v0__xor2_1_0/Z VSS -0.06499f
C1484 gf180mcu_fd_sc_mcu7t5v0__dlyb_1_0/I VSS -0.28889f
C1485 gf180mcu_fd_sc_mcu7t5v0__dffq_1_2/D VSS 0.06015f
C1486 gf180mcu_fd_sc_mcu7t5v0__xnor2_1_1/A2 VSS 0.03881f
C1487 gf180mcu_fd_sc_mcu7t5v0__dffq_1_2/CLK VSS -0.0583f
C1488 gf180mcu_fd_sc_mcu7t5v0__dffq_1_0/D VSS -0.25731f
C1489 gf180mcu_fd_sc_mcu7t5v0__xnor2_1_0/A2 VSS -0.12601f
C1490 gf180mcu_fd_sc_mcu7t5v0__dlyb_1_3/I VSS -0.35974f
C1491 gf180mcu_fd_sc_mcu7t5v0__dlyb_1_2/I VSS -0.13096f
C1492 clk.n0 VSS 0.00658f
C1493 clk.n1 VSS 0.00243f
C1494 clk.n2 VSS 0.00434f
C1495 clk.n3 VSS 0.01195f
C1496 clk.n4 VSS 0.00243f
C1497 clk.n5 VSS 0.00434f
C1498 clk.n6 VSS 0.00843f
C1499 clk.n7 VSS 0.00628f
C1500 clk.n8 VSS 0.00243f
C1501 clk.n9 VSS 0.00434f
C1502 clk.n10 VSS 0.01187f
C1503 clk.n11 VSS 0.00243f
C1504 clk.n12 VSS 0.00434f
C1505 clk.n13 VSS 0.00843f
C1506 clk.n14 VSS 0.00243f
C1507 clk.n15 VSS 0.00434f
C1508 clk.n16 VSS 0.00843f
C1509 clk.n17 VSS 0.00243f
C1510 clk.n18 VSS 0.00434f
C1511 clk.n19 VSS 0.01002f
C1512 VSS.n0 VSS 0.04278f
C1513 VSS.n1 VSS 0.03984f
C1514 VSS.n2 VSS 0.00925f
C1515 VSS.n3 VSS 0.00925f
C1516 VSS.n4 VSS 0.00925f
C1517 VSS.n5 VSS 0.00925f
C1518 VSS.n6 VSS 0.00925f
C1519 VSS.n7 VSS 0.00855f
C1520 VSS.n8 VSS 0.00855f
C1521 VSS.n9 VSS 0.00855f
C1522 VSS.n10 VSS 0.00557f
C1523 VSS.n11 VSS 0.00557f
C1524 VSS.n12 VSS 0
C1525 VSS.n13 VSS 0.00323f
C1526 VSS.n14 VSS 0.1056f
C1527 VSS.n15 VSS 0.05431f
C1528 VSS.n16 VSS 0.00637f
C1529 VSS.n17 VSS 0.00464f
C1530 VSS.n18 VSS 0.01339f
C1531 VSS.n19 VSS 0.00882f
C1532 VSS.n20 VSS 0.00882f
C1533 VSS.n21 VSS 0
C1534 VSS.n22 VSS 0.00226f
C1535 VSS.n23 VSS 0.08318f
C1536 VSS.n24 VSS 0.01207f
C1537 VSS.n25 VSS 0.00882f
C1538 VSS.n26 VSS 0
C1539 VSS.n27 VSS 0.00878f
C1540 VSS.n28 VSS 0.00269f
C1541 VSS.n29 VSS 0.03152f
C1542 VSS.n30 VSS 0.10769f
C1543 VSS.n31 VSS 0.03336f
C1544 VSS.n32 VSS 0.00215f
C1545 VSS.n33 VSS 0
C1546 VSS.n34 VSS 0.00882f
C1547 VSS.n35 VSS 0.00855f
C1548 VSS.n36 VSS 0.00882f
C1549 VSS.n37 VSS 0.00238f
C1550 VSS.n38 VSS 0
C1551 VSS.n39 VSS 0.00882f
C1552 VSS.n40 VSS 0.00855f
C1553 VSS.n41 VSS 0.23007f
C1554 VSS.n42 VSS 0.00853f
C1555 VSS.n43 VSS 0.17956f
C1556 VSS.n44 VSS 0.22273f
C1557 VSS.n45 VSS 0.17014f
C1558 VSS.n46 VSS 0.17014f
C1559 VSS.n47 VSS 0.17014f
C1560 VSS.n48 VSS 0.66291f
C1561 VSS.n49 VSS 0.65868f
C1562 VSS.n50 VSS 0.1682f
C1563 VSS.n51 VSS 0.1682f
C1564 VSS.n52 VSS 0.1682f
C1565 VSS.n53 VSS 0.20293f
C1566 VSS.n54 VSS 0.29698f
C1567 VSS.n55 VSS 0.00174f
C1568 VSS.n56 VSS 0.00956f
C1569 VSS.n57 VSS 0.02289f
C1570 VDD.n0 VSS 0.00902f
C1571 VDD.n1 VSS 0.01712f
C1572 VDD.n2 VSS 0.13685f
C1573 VDD.n3 VSS 0.07338f
C1574 VDD.n4 VSS 0.01245f
C1575 VDD.n5 VSS 0.02182f
C1576 VDD.n6 VSS 0.00617f
C1577 VDD.n7 VSS 0.02182f
C1578 VDD.n8 VSS 0.01584f
C1579 VDD.n9 VSS 0.00616f
C1580 VDD.n10 VSS 0.10678f
C1581 VDD.n11 VSS 0.02182f
C1582 VDD.n12 VSS 0.00702f
C1583 VDD.n13 VSS 0.02844f
C1584 VDD.n14 VSS 0.00997f
C1585 VDD.n15 VSS 0.01619f
C1586 VDD.n16 VSS 0.07099f
C1587 VDD.n17 VSS 0.02182f
C1588 VDD.n18 VSS 0.00617f
C1589 VDD.n19 VSS 0.02182f
C1590 VDD.n20 VSS 0.00411f
C1591 VDD.n21 VSS 0.04959f
C1592 VDD.n22 VSS 0.17181f
C1593 VDD.n23 VSS 0.02182f
C1594 VDD.n24 VSS 0.00617f
C1595 VDD.n25 VSS 0.0152f
C1596 VDD.n26 VSS 0.02979f
C1597 VDD.n27 VSS 0.05808f
C1598 VDD.n28 VSS 0.2188f
C1599 VDD.n29 VSS 0.0152f
C1600 VDD.n30 VSS 0.00635f
C1601 VDD.n31 VSS 0.00819f
C1602 VDD.n32 VSS 0.00538f
C1603 VDD.n33 VSS 0.04167f
C1604 VDD.n34 VSS 0.00311f
C1605 VDD.n35 VSS 0.05515f
C1606 gf180mcu_fd_sc_mcu7t5v0__clkbuf_16_2/Z VSS 1.03777f
C1607 gf180mcu_fd_sc_mcu7t5v0__fillcap_8_1/a_484_472# VSS 0.00881f
C1608 gf180mcu_fd_sc_mcu7t5v0__fillcap_8_1/a_36_472# VSS 0.00893f
C1609 gf180mcu_fd_sc_mcu7t5v0__fillcap_8_1/a_572_375# VSS 0.06563f
C1610 gf180mcu_fd_sc_mcu7t5v0__fillcap_8_1/a_124_375# VSS 0.0131f
C1611 gf180mcu_fd_sc_mcu7t5v0__fillcap_8_0/a_484_472# VSS 0.0033f
C1612 gf180mcu_fd_sc_mcu7t5v0__fillcap_8_0/a_36_472# VSS 0.00159f
C1613 gf180mcu_fd_sc_mcu7t5v0__fillcap_8_0/a_572_375# VSS 0.05536f
C1614 gf180mcu_fd_sc_mcu7t5v0__nand2_1_0/a_245_68# VSS 0
C1615 gf180mcu_fd_sc_mcu7t5v0__clkbuf_16_2/a_224_552# VSS 0.21411f
C1616 gf180mcu_fd_sc_mcu7t5v0__dffq_1_3/a_2304_115# VSS -0
C1617 gf180mcu_fd_sc_mcu7t5v0__dffq_1_3/a_2011_527# VSS 0
C1618 gf180mcu_fd_sc_mcu7t5v0__dffq_1_3/a_1004_159# VSS -0
C1619 gf180mcu_fd_sc_mcu7t5v0__dffq_1_3/a_1376_115# VSS 0
C1620 gf180mcu_fd_sc_mcu7t5v0__dffq_1_3/a_448_472# VSS 0
C1621 gf180mcu_fd_sc_mcu7t5v0__dffq_1_3/a_36_151# VSS 0.05677f
C1622 gf180mcu_fd_sc_mcu7t5v0__clkbuf_16_1/a_224_552# VSS 0.11097f
C1623 gf180mcu_fd_sc_mcu7t5v0__dffq_1_2/a_1328_159# VSS 0
C1624 gf180mcu_fd_sc_mcu7t5v0__dffq_1_2/a_836_159# VSS 0
C1625 gf180mcu_fd_sc_mcu7t5v0__dffq_1_2/a_1348_527# VSS 0
C1626 gf180mcu_fd_sc_mcu7t5v0__dffq_1_2/a_880_527# VSS 0
C1627 gf180mcu_fd_sc_mcu7t5v0__dffq_1_2/a_2304_115# VSS 0.0027f
C1628 gf180mcu_fd_sc_mcu7t5v0__dffq_1_2/a_2011_527# VSS 0.00299f
C1629 gf180mcu_fd_sc_mcu7t5v0__dffq_1_2/a_1004_159# VSS 0.03587f
C1630 gf180mcu_fd_sc_mcu7t5v0__dffq_1_2/a_1376_115# VSS 0.04221f
C1631 gf180mcu_fd_sc_mcu7t5v0__dffq_1_2/a_448_472# VSS 0.03711f
C1632 gf180mcu_fd_sc_mcu7t5v0__dffq_1_2/a_36_151# VSS 0.05461f
C1633 gf180mcu_fd_sc_mcu7t5v0__clkbuf_16_0/a_224_552# VSS 0.10419f
C1634 gf180mcu_fd_sc_mcu7t5v0__dffq_1_1/a_2304_115# VSS 0.00267f
C1635 gf180mcu_fd_sc_mcu7t5v0__dffq_1_1/a_2011_527# VSS 0.00102f
C1636 gf180mcu_fd_sc_mcu7t5v0__dffq_1_1/a_1004_159# VSS 0
C1637 gf180mcu_fd_sc_mcu7t5v0__dffq_1_1/a_1376_115# VSS 0.00109f
C1638 gf180mcu_fd_sc_mcu7t5v0__dffq_1_1/a_448_472# VSS 0
C1639 gf180mcu_fd_sc_mcu7t5v0__dffq_1_1/a_36_151# VSS 0.02568f
C1640 gf180mcu_fd_sc_mcu7t5v0__dffq_1_0/a_2304_115# VSS 0.00239f
C1641 gf180mcu_fd_sc_mcu7t5v0__dffq_1_0/a_2011_527# VSS -0
C1642 gf180mcu_fd_sc_mcu7t5v0__dffq_1_0/a_1004_159# VSS -0
C1643 gf180mcu_fd_sc_mcu7t5v0__dffq_1_0/a_448_472# VSS 0
C1644 gf180mcu_fd_sc_mcu7t5v0__dffq_1_0/a_36_151# VSS 0.01441f
C1645 gf180mcu_fd_sc_mcu7t5v0__xor2_1_0/a_952_68# VSS 0
C1646 gf180mcu_fd_sc_mcu7t5v0__xor2_1_0/a_56_604# VSS 0.00101f
C1647 gf180mcu_fd_sc_mcu7t5v0__nand3_1_0/a_455_68# VSS 0
C1648 gf180mcu_fd_sc_mcu7t5v0__nand3_1_0/a_271_68# VSS 0.00119f
C1649 gf180mcu_fd_sc_mcu7t5v0__fillcap_4_13/a_36_472# VSS 0.01196f
C1650 gf180mcu_fd_sc_mcu7t5v0__fillcap_4_13/a_124_375# VSS 0.06184f
C1651 gf180mcu_fd_sc_mcu7t5v0__fillcap_16_2/a_1380_472# VSS 0.01412f
C1652 gf180mcu_fd_sc_mcu7t5v0__fillcap_16_2/a_932_472# VSS 0.00268f
C1653 gf180mcu_fd_sc_mcu7t5v0__fillcap_16_2/a_484_472# VSS 0.00227f
C1654 gf180mcu_fd_sc_mcu7t5v0__fillcap_16_2/a_36_472# VSS 0.00371f
C1655 gf180mcu_fd_sc_mcu7t5v0__fillcap_16_2/a_1468_375# VSS 0.04534f
C1656 gf180mcu_fd_sc_mcu7t5v0__fillcap_16_2/a_1020_375# VSS 0.00189f
C1657 gf180mcu_fd_sc_mcu7t5v0__fillcap_16_2/a_572_375# VSS 0.00578f
C1658 gf180mcu_fd_sc_mcu7t5v0__fillcap_16_2/a_124_375# VSS 0.00634f
C1659 gf180mcu_fd_sc_mcu7t5v0__fillcap_4_12/a_36_472# VSS 0.00984f
C1660 gf180mcu_fd_sc_mcu7t5v0__fillcap_4_12/a_124_375# VSS 0.02467f
C1661 gf180mcu_fd_sc_mcu7t5v0__fillcap_16_1/a_1380_472# VSS 0.01172f
C1662 gf180mcu_fd_sc_mcu7t5v0__fillcap_16_1/a_932_472# VSS 0
C1663 gf180mcu_fd_sc_mcu7t5v0__fillcap_16_1/a_484_472# VSS 0
C1664 gf180mcu_fd_sc_mcu7t5v0__fillcap_16_1/a_36_472# VSS 0.00136f
C1665 gf180mcu_fd_sc_mcu7t5v0__fillcap_16_1/a_1468_375# VSS 0.06184f
C1666 gf180mcu_fd_sc_mcu7t5v0__fillcap_32_6/a_3172_472# VSS 0.00519f
C1667 gf180mcu_fd_sc_mcu7t5v0__fillcap_32_6/a_2724_472# VSS 0.00165f
C1668 gf180mcu_fd_sc_mcu7t5v0__fillcap_32_6/a_2276_472# VSS 0.00165f
C1669 gf180mcu_fd_sc_mcu7t5v0__fillcap_32_6/a_1828_472# VSS 0
C1670 gf180mcu_fd_sc_mcu7t5v0__fillcap_32_6/a_1380_472# VSS 0.00319f
C1671 gf180mcu_fd_sc_mcu7t5v0__fillcap_32_6/a_932_472# VSS 0.00472f
C1672 gf180mcu_fd_sc_mcu7t5v0__fillcap_32_6/a_484_472# VSS 0.00686f
C1673 gf180mcu_fd_sc_mcu7t5v0__fillcap_32_6/a_36_472# VSS 0.0165f
C1674 gf180mcu_fd_sc_mcu7t5v0__fillcap_32_6/a_3260_375# VSS 0.04913f
C1675 gf180mcu_fd_sc_mcu7t5v0__fillcap_32_6/a_1468_375# VSS 0.00192f
C1676 gf180mcu_fd_sc_mcu7t5v0__fillcap_32_6/a_1020_375# VSS 0.00405f
C1677 gf180mcu_fd_sc_mcu7t5v0__fillcap_32_6/a_572_375# VSS 0.00607f
C1678 gf180mcu_fd_sc_mcu7t5v0__fillcap_32_6/a_124_375# VSS 0.01249f
C1679 gf180mcu_fd_sc_mcu7t5v0__fillcap_4_11/a_36_472# VSS 0.0055f
C1680 gf180mcu_fd_sc_mcu7t5v0__fillcap_4_11/a_124_375# VSS 0.02753f
C1681 gf180mcu_fd_sc_mcu7t5v0__fillcap_32_5/a_3172_472# VSS 0.00758f
C1682 gf180mcu_fd_sc_mcu7t5v0__fillcap_32_5/a_2724_472# VSS 0.00435f
C1683 gf180mcu_fd_sc_mcu7t5v0__fillcap_32_5/a_2276_472# VSS 0.00435f
C1684 gf180mcu_fd_sc_mcu7t5v0__fillcap_32_5/a_1828_472# VSS 0.00356f
C1685 gf180mcu_fd_sc_mcu7t5v0__fillcap_32_5/a_1380_472# VSS 0.00585f
C1686 gf180mcu_fd_sc_mcu7t5v0__fillcap_32_5/a_932_472# VSS 0.00799f
C1687 gf180mcu_fd_sc_mcu7t5v0__fillcap_32_5/a_484_472# VSS 0.00996f
C1688 gf180mcu_fd_sc_mcu7t5v0__fillcap_32_5/a_36_472# VSS 0.01705f
C1689 gf180mcu_fd_sc_mcu7t5v0__fillcap_32_5/a_3260_375# VSS 0.05981f
C1690 gf180mcu_fd_sc_mcu7t5v0__fillcap_32_5/a_2812_375# VSS 0.00446f
C1691 gf180mcu_fd_sc_mcu7t5v0__fillcap_32_5/a_2364_375# VSS 0.00446f
C1692 gf180mcu_fd_sc_mcu7t5v0__fillcap_32_5/a_1916_375# VSS 0.00361f
C1693 gf180mcu_fd_sc_mcu7t5v0__fillcap_32_5/a_1468_375# VSS 0.00518f
C1694 gf180mcu_fd_sc_mcu7t5v0__fillcap_32_5/a_1020_375# VSS 0.00844f
C1695 gf180mcu_fd_sc_mcu7t5v0__fillcap_32_5/a_572_375# VSS 0.00996f
C1696 gf180mcu_fd_sc_mcu7t5v0__fillcap_32_5/a_124_375# VSS 0.01521f
C1697 gf180mcu_fd_sc_mcu7t5v0__fillcap_16_0/a_1380_472# VSS 0.00191f
C1698 gf180mcu_fd_sc_mcu7t5v0__fillcap_16_0/a_932_472# VSS -0.00132f
C1699 gf180mcu_fd_sc_mcu7t5v0__fillcap_16_0/a_484_472# VSS -0.00132f
C1700 gf180mcu_fd_sc_mcu7t5v0__fillcap_16_0/a_36_472# VSS 0.00204f
C1701 gf180mcu_fd_sc_mcu7t5v0__fillcap_16_0/a_1468_375# VSS 0.0567f
C1702 gf180mcu_fd_sc_mcu7t5v0__fillcap_16_0/a_1020_375# VSS 0.00135f
C1703 gf180mcu_fd_sc_mcu7t5v0__fillcap_16_0/a_572_375# VSS 0
C1704 gf180mcu_fd_sc_mcu7t5v0__fillcap_16_0/a_124_375# VSS 0.00207f
C1705 gf180mcu_fd_sc_mcu7t5v0__fillcap_4_9/a_36_472# VSS 0.00244f
C1706 gf180mcu_fd_sc_mcu7t5v0__fillcap_4_9/a_124_375# VSS 0.02735f
C1707 gf180mcu_fd_sc_mcu7t5v0__fillcap_4_10/a_36_472# VSS 0.00501f
C1708 gf180mcu_fd_sc_mcu7t5v0__fillcap_4_10/a_124_375# VSS 0.01788f
C1709 gf180mcu_fd_sc_mcu7t5v0__fillcap_4_8/a_36_472# VSS 0.00949f
C1710 gf180mcu_fd_sc_mcu7t5v0__fillcap_4_8/a_124_375# VSS 0.02219f
C1711 gf180mcu_fd_sc_mcu7t5v0__fillcap_32_4/a_3172_472# VSS 0.00134f
C1712 gf180mcu_fd_sc_mcu7t5v0__fillcap_32_4/a_2724_472# VSS -0.00189f
C1713 gf180mcu_fd_sc_mcu7t5v0__fillcap_32_4/a_2276_472# VSS -0.00189f
C1714 gf180mcu_fd_sc_mcu7t5v0__fillcap_32_4/a_1828_472# VSS -0.00189f
C1715 gf180mcu_fd_sc_mcu7t5v0__fillcap_32_4/a_1380_472# VSS -0
C1716 gf180mcu_fd_sc_mcu7t5v0__fillcap_32_4/a_932_472# VSS 0.00466f
C1717 gf180mcu_fd_sc_mcu7t5v0__fillcap_32_4/a_484_472# VSS 0.0075f
C1718 gf180mcu_fd_sc_mcu7t5v0__fillcap_32_4/a_36_472# VSS 0.01371f
C1719 gf180mcu_fd_sc_mcu7t5v0__fillcap_32_4/a_3260_375# VSS 0.05536f
C1720 gf180mcu_fd_sc_mcu7t5v0__fillcap_32_4/a_1468_375# VSS 0
C1721 gf180mcu_fd_sc_mcu7t5v0__fillcap_32_4/a_1020_375# VSS 0.00283f
C1722 gf180mcu_fd_sc_mcu7t5v0__fillcap_32_4/a_572_375# VSS 0.0055f
C1723 gf180mcu_fd_sc_mcu7t5v0__fillcap_32_4/a_124_375# VSS 0.01182f
C1724 gf180mcu_fd_sc_mcu7t5v0__fillcap_32_3/a_3172_472# VSS 0.00546f
C1725 gf180mcu_fd_sc_mcu7t5v0__fillcap_32_3/a_2724_472# VSS 0.00345f
C1726 gf180mcu_fd_sc_mcu7t5v0__fillcap_32_3/a_2276_472# VSS 0.00345f
C1727 gf180mcu_fd_sc_mcu7t5v0__fillcap_32_3/a_1828_472# VSS 0.00345f
C1728 gf180mcu_fd_sc_mcu7t5v0__fillcap_32_3/a_1380_472# VSS 0.00496f
C1729 gf180mcu_fd_sc_mcu7t5v0__fillcap_32_3/a_932_472# VSS 0.00709f
C1730 gf180mcu_fd_sc_mcu7t5v0__fillcap_32_3/a_484_472# VSS 0.00907f
C1731 gf180mcu_fd_sc_mcu7t5v0__fillcap_32_3/a_36_472# VSS 0.01675f
C1732 gf180mcu_fd_sc_mcu7t5v0__fillcap_32_3/a_3260_375# VSS 0.06116f
C1733 gf180mcu_fd_sc_mcu7t5v0__fillcap_32_3/a_2812_375# VSS 0.0058f
C1734 gf180mcu_fd_sc_mcu7t5v0__fillcap_32_3/a_2364_375# VSS 0.0058f
C1735 gf180mcu_fd_sc_mcu7t5v0__fillcap_32_3/a_1916_375# VSS 0.00433f
C1736 gf180mcu_fd_sc_mcu7t5v0__fillcap_32_3/a_1468_375# VSS 0.00652f
C1737 gf180mcu_fd_sc_mcu7t5v0__fillcap_32_3/a_1020_375# VSS 0.00944f
C1738 gf180mcu_fd_sc_mcu7t5v0__fillcap_32_3/a_572_375# VSS 0.01129f
C1739 gf180mcu_fd_sc_mcu7t5v0__fillcap_32_3/a_124_375# VSS 0.01764f
C1740 gf180mcu_fd_sc_mcu7t5v0__fillcap_4_7/a_36_472# VSS 0.00585f
C1741 gf180mcu_fd_sc_mcu7t5v0__fillcap_4_7/a_124_375# VSS 0.00533f
C1742 gf180mcu_fd_sc_mcu7t5v0__dlyb_1_3/a_1127_622# VSS 0
C1743 gf180mcu_fd_sc_mcu7t5v0__dlyb_1_3/a_895_68# VSS 0.00432f
C1744 gf180mcu_fd_sc_mcu7t5v0__dlyb_1_3/a_671_644# VSS 0.00169f
C1745 gf180mcu_fd_sc_mcu7t5v0__dlyb_1_3/a_503_644# VSS 0
C1746 gf180mcu_fd_sc_mcu7t5v0__dlyb_1_3/a_47_68# VSS 0.00226f
C1747 gf180mcu_fd_sc_mcu7t5v0__fillcap_4_6/a_36_472# VSS 0.00603f
C1748 gf180mcu_fd_sc_mcu7t5v0__fillcap_4_6/a_124_375# VSS 0.00703f
C1749 gf180mcu_fd_sc_mcu7t5v0__fillcap_32_2/a_3172_472# VSS 0.00354f
C1750 gf180mcu_fd_sc_mcu7t5v0__fillcap_32_2/a_1380_472# VSS 0.00253f
C1751 gf180mcu_fd_sc_mcu7t5v0__fillcap_32_2/a_932_472# VSS 0.00406f
C1752 gf180mcu_fd_sc_mcu7t5v0__fillcap_32_2/a_484_472# VSS 0.0062f
C1753 gf180mcu_fd_sc_mcu7t5v0__fillcap_32_2/a_36_472# VSS 0.01584f
C1754 gf180mcu_fd_sc_mcu7t5v0__fillcap_32_2/a_3260_375# VSS 0.04913f
C1755 gf180mcu_fd_sc_mcu7t5v0__fillcap_32_2/a_1916_375# VSS 0
C1756 gf180mcu_fd_sc_mcu7t5v0__fillcap_32_2/a_1468_375# VSS 0.00192f
C1757 gf180mcu_fd_sc_mcu7t5v0__fillcap_32_2/a_1020_375# VSS 0.00405f
C1758 gf180mcu_fd_sc_mcu7t5v0__fillcap_32_2/a_572_375# VSS 0.00607f
C1759 gf180mcu_fd_sc_mcu7t5v0__fillcap_32_2/a_124_375# VSS 0.01249f
C1760 gf180mcu_fd_sc_mcu7t5v0__dlyb_1_2/a_1147_68# VSS 0
C1761 gf180mcu_fd_sc_mcu7t5v0__dlyb_1_2/a_523_68# VSS 0
C1762 gf180mcu_fd_sc_mcu7t5v0__dlyb_1_2/a_895_68# VSS 0.00208f
C1763 gf180mcu_fd_sc_mcu7t5v0__dlyb_1_2/a_671_644# VSS 0
C1764 gf180mcu_fd_sc_mcu7t5v0__dlyb_1_2/a_47_68# VSS 0.03983f
C1765 gf180mcu_fd_sc_mcu7t5v0__fillcap_32_1/a_3172_472# VSS 0.00323f
C1766 gf180mcu_fd_sc_mcu7t5v0__fillcap_32_1/a_2724_472# VSS 0
C1767 gf180mcu_fd_sc_mcu7t5v0__fillcap_32_1/a_1380_472# VSS 0.0015f
C1768 gf180mcu_fd_sc_mcu7t5v0__fillcap_32_1/a_932_472# VSS 0.00364f
C1769 gf180mcu_fd_sc_mcu7t5v0__fillcap_32_1/a_484_472# VSS 0.00561f
C1770 gf180mcu_fd_sc_mcu7t5v0__fillcap_32_1/a_36_472# VSS 0.01373f
C1771 gf180mcu_fd_sc_mcu7t5v0__fillcap_32_1/a_3260_375# VSS 0.05564f
C1772 gf180mcu_fd_sc_mcu7t5v0__fillcap_32_1/a_2812_375# VSS 0
C1773 gf180mcu_fd_sc_mcu7t5v0__fillcap_32_1/a_2364_375# VSS 0
C1774 gf180mcu_fd_sc_mcu7t5v0__fillcap_32_1/a_1916_375# VSS 0
C1775 gf180mcu_fd_sc_mcu7t5v0__fillcap_32_1/a_1468_375# VSS 0.00116f
C1776 gf180mcu_fd_sc_mcu7t5v0__fillcap_32_1/a_1020_375# VSS 0.00409f
C1777 gf180mcu_fd_sc_mcu7t5v0__fillcap_32_1/a_572_375# VSS 0.00594f
C1778 gf180mcu_fd_sc_mcu7t5v0__fillcap_32_1/a_124_375# VSS 0.01229f
C1779 gf180mcu_fd_sc_mcu7t5v0__fillcap_4_5/a_36_472# VSS 0.00268f
C1780 gf180mcu_fd_sc_mcu7t5v0__fillcap_4_5/a_124_375# VSS 0.00274f
C1781 VDD VSS -71.05157f
C1782 gf180mcu_fd_sc_mcu7t5v0__dlyb_1_1/a_1147_68# VSS 0
C1783 gf180mcu_fd_sc_mcu7t5v0__dlyb_1_1/a_523_68# VSS 0
C1784 gf180mcu_fd_sc_mcu7t5v0__dlyb_1_1/a_895_68# VSS 0.00322f
C1785 gf180mcu_fd_sc_mcu7t5v0__dlyb_1_1/a_671_644# VSS 0
C1786 gf180mcu_fd_sc_mcu7t5v0__dlyb_1_1/a_47_68# VSS 0.03912f
C1787 gf180mcu_fd_sc_mcu7t5v0__xnor2_1_1/a_716_68# VSS 0.00992f
C1788 gf180mcu_fd_sc_mcu7t5v0__xnor2_1_1/a_272_93# VSS 0
C1789 gf180mcu_fd_sc_mcu7t5v0__xnor2_1_1/a_64_93# VSS 0.00719f
C1790 gf180mcu_fd_sc_mcu7t5v0__fillcap_32_0/a_3172_472# VSS 0.00371f
C1791 gf180mcu_fd_sc_mcu7t5v0__fillcap_32_0/a_2724_472# VSS 0.00132f
C1792 gf180mcu_fd_sc_mcu7t5v0__fillcap_32_0/a_2276_472# VSS 0.00132f
C1793 gf180mcu_fd_sc_mcu7t5v0__fillcap_32_0/a_1828_472# VSS 0.00145f
C1794 gf180mcu_fd_sc_mcu7t5v0__fillcap_32_0/a_1380_472# VSS 0.00426f
C1795 gf180mcu_fd_sc_mcu7t5v0__fillcap_32_0/a_932_472# VSS 0.00584f
C1796 gf180mcu_fd_sc_mcu7t5v0__fillcap_32_0/a_484_472# VSS 0.00828f
C1797 gf180mcu_fd_sc_mcu7t5v0__fillcap_32_0/a_36_472# VSS 0.03976f
C1798 gf180mcu_fd_sc_mcu7t5v0__fillcap_32_0/a_3260_375# VSS 0.01379f
C1799 gf180mcu_fd_sc_mcu7t5v0__fillcap_32_0/a_2812_375# VSS 0
C1800 gf180mcu_fd_sc_mcu7t5v0__fillcap_32_0/a_2364_375# VSS 0
C1801 gf180mcu_fd_sc_mcu7t5v0__fillcap_32_0/a_1916_375# VSS 0
C1802 gf180mcu_fd_sc_mcu7t5v0__fillcap_32_0/a_1468_375# VSS 0.00364f
C1803 gf180mcu_fd_sc_mcu7t5v0__fillcap_32_0/a_1020_375# VSS 0.00515f
C1804 gf180mcu_fd_sc_mcu7t5v0__fillcap_32_0/a_572_375# VSS 0.00731f
C1805 gf180mcu_fd_sc_mcu7t5v0__fillcap_32_0/a_124_375# VSS 0.01545f
C1806 gf180mcu_fd_sc_mcu7t5v0__fillcap_4_4/a_36_472# VSS 0.00598f
C1807 gf180mcu_fd_sc_mcu7t5v0__fillcap_4_4/a_124_375# VSS 0.02885f
C1808 gf180mcu_fd_sc_mcu7t5v0__dlyb_1_0/a_1147_68# VSS 0
C1809 gf180mcu_fd_sc_mcu7t5v0__dlyb_1_0/a_523_68# VSS 0
C1810 gf180mcu_fd_sc_mcu7t5v0__dlyb_1_0/a_1127_622# VSS 0
C1811 gf180mcu_fd_sc_mcu7t5v0__dlyb_1_0/a_895_68# VSS 0.00741f
C1812 gf180mcu_fd_sc_mcu7t5v0__dlyb_1_0/a_671_644# VSS 0.00658f
C1813 gf180mcu_fd_sc_mcu7t5v0__dlyb_1_0/a_503_644# VSS 0
C1814 gf180mcu_fd_sc_mcu7t5v0__dlyb_1_0/a_47_68# VSS 0.05293f
C1815 gf180mcu_fd_sc_mcu7t5v0__xnor2_1_0/a_716_68# VSS 0.00792f
C1816 gf180mcu_fd_sc_mcu7t5v0__xnor2_1_0/a_272_93# VSS 0
C1817 gf180mcu_fd_sc_mcu7t5v0__xnor2_1_0/a_64_93# VSS 0.00116f
C1818 gf180mcu_fd_sc_mcu7t5v0__fillcap_4_3/a_36_472# VSS 0.00256f
C1819 gf180mcu_fd_sc_mcu7t5v0__fillcap_4_3/a_124_375# VSS 0.00348f
C1820 gf180mcu_fd_sc_mcu7t5v0__fillcap_4_2/a_36_472# VSS 0.00724f
C1821 gf180mcu_fd_sc_mcu7t5v0__fillcap_4_2/a_124_375# VSS 0.02361f
C1822 gf180mcu_fd_sc_mcu7t5v0__fillcap_4_1/a_36_472# VSS 0.00481f
C1823 gf180mcu_fd_sc_mcu7t5v0__fillcap_4_1/a_124_375# VSS 0.02797f
C1824 gf180mcu_fd_sc_mcu7t5v0__fillcap_4_0/a_36_472# VSS 0.00509f
C1825 gf180mcu_fd_sc_mcu7t5v0__fillcap_4_0/a_124_375# VSS 0.01773f
C1826 clk VSS 0.49254f
.ends
